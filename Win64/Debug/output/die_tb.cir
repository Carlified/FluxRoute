* die_tb.cir - generated by make_tb.py
* clock period 100 ps, 8 slots, launch offset 50 ps

.include C:\Users\27005348\Documents\Embarcadero\Studio\Projects\Win64\Debug\output\die.cir
.include C:\Users\27005348\Desktop\RSFQlib\mitll_DCSFQ-PTLTX\THmitll_DCSFQ-PTLTX_v3p0_extracted.cir
.include C:\Users\27005348\Desktop\RSFQlib\mitll_PTLRX-SFQDC\THmitll_PTLRX-SFQDC_v3p0_extracted.cir

* ===== clock =====
I_clk 0 nclk pulse(0 600u 50p 2p 2p 3p 100p)
XSCLK THmitll_DCSFQ-PTLTX nclk clk_i

* ===== data inputs =====
* a = 11010010
I_a 0 na pwl(0 0 50p 0 53p 600u 56p 0 150p 0 153p 600u 156p 0 350p 0 353p 600u 356p 0 650p 0 653p 600u 656p 0)
XSa THmitll_DCSFQ-PTLTX na a_i
* b = 01110101
I_b 0 nb pwl(0 0 150p 0 153p 600u 156p 0 250p 0 253p 600u 256p 0 350p 0 353p 600u 356p 0 550p 0 553p 600u 556p 0 750p 0 753p 600u 756p 0)
XSb THmitll_DCSFQ-PTLTX nb b_i
* cin = 00011011
I_cin 0 ncin pwl(0 0 350p 0 353p 600u 356p 0 450p 0 453p 600u 456p 0 650p 0 653p 600u 656p 0 750p 0 753p 600u 756p 0)
XScin THmitll_DCSFQ-PTLTX ncin cin_i

* ===== readout =====
XRsum THmitll_PTLRX-SFQDC sum_o rsum
Rsum rsum 0 2
XRcout THmitll_PTLRX-SFQDC cout_o rcout
Rcout rcout 0 2

* ===== analysis =====
.tran 0.025p 1000p 0
.print p(B3.XSCLK) p(B1.XRsum) p(B1.XRcout) v(rsum) v(rcout)
.end
