* BEND_PTL_M1 - ideal (lossless) PTL segment, 10 um block.
.subckt BEND_PTL_M1 P0 P1
T0 P0 0 P1 0 LOSSLESS Z0=5.3 TD=1p
.ends
