* hamming74_tb.cir - generated by make_tb.py
* clock period 125 ps, 32 slots
* clock launch 50 ps, data launch 169.35 ps (data-clock 119.35 ps)
* input window 68.2 .. 170.5 ps relative to clock send

.include hamming74.cir
.include lib/THmitll_DCSFQ-PTLTX_v3p0_extracted.cir
.include lib/THmitll_PTLRX-SFQDC_v3p0_extracted.cir

* ===== clock =====
I_clk 0 nclk pulse(0 600u 50p 2p 2p 3p 125p)
XSCLK THmitll_DCSFQ-PTLTX nclk clk_i

* ===== data inputs =====
* r1 = 11111111111111111111111111111111
I_r1 0 nr1 PWL(0 0 169.35p 0 172.35p 600u 175.35p 0 294.35p 0 297.35p 600u 300.35p 0 419.35p 0 422.35p 600u 425.35p 0 544.35p 0 547.35p 600u 550.35p 0 669.35p 0 672.35p 600u 675.35p 0 794.35p 0 797.35p 600u 800.35p 0 919.35p 0 922.35p 600u 925.35p 0 1044.35p 0 1047.35p 600u 1050.35p 0 1169.35p 0 1172.35p 600u 1175.35p 0 1294.35p 0 1297.35p 600u 1300.35p 0 1419.35p 0 1422.35p 600u 1425.35p 0 1544.35p 0 1547.35p 600u 1550.35p 0 1669.35p 0 1672.35p 600u 1675.35p 0 1794.35p 0 1797.35p 600u 1800.35p 0 1919.35p 0 1922.35p 600u 1925.35p 0 2044.35p 0 2047.35p 600u 2050.35p 0 2169.35p 0 2172.35p 600u 2175.35p 0 2294.35p 0 2297.35p 600u 2300.35p 0 2419.35p 0 2422.35p 600u 2425.35p 0 2544.35p 0 2547.35p 600u 2550.35p 0 2669.35p 0 2672.35p 600u 2675.35p 0 2794.35p 0 2797.35p 600u 2800.35p 0 2919.35p 0 2922.35p 600u 2925.35p 0 3044.35p 0 3047.35p 600u 3050.35p 0 3169.35p 0 3172.35p 600u 3175.35p 0 3294.35p 0 3297.35p 600u 3300.35p 0 3419.35p 0 3422.35p 600u 3425.35p 0 3544.35p 0 3547.35p 600u 3550.35p 0 3669.35p 0 3672.35p 600u 3675.35p 0 3794.35p 0 3797.35p 600u 3800.35p 0 3919.35p 0 3922.35p 600u 3925.35p 0 4044.35p 0 4047.35p 600u 4050.35p 0)
XSr1 THmitll_DCSFQ-PTLTX nr1 r1_i
* r2 = 11111111111111111111111111111111
I_r2 0 nr2 PWL(0 0 169.35p 0 172.35p 600u 175.35p 0 294.35p 0 297.35p 600u 300.35p 0 419.35p 0 422.35p 600u 425.35p 0 544.35p 0 547.35p 600u 550.35p 0 669.35p 0 672.35p 600u 675.35p 0 794.35p 0 797.35p 600u 800.35p 0 919.35p 0 922.35p 600u 925.35p 0 1044.35p 0 1047.35p 600u 1050.35p 0 1169.35p 0 1172.35p 600u 1175.35p 0 1294.35p 0 1297.35p 600u 1300.35p 0 1419.35p 0 1422.35p 600u 1425.35p 0 1544.35p 0 1547.35p 600u 1550.35p 0 1669.35p 0 1672.35p 600u 1675.35p 0 1794.35p 0 1797.35p 600u 1800.35p 0 1919.35p 0 1922.35p 600u 1925.35p 0 2044.35p 0 2047.35p 600u 2050.35p 0 2169.35p 0 2172.35p 600u 2175.35p 0 2294.35p 0 2297.35p 600u 2300.35p 0 2419.35p 0 2422.35p 600u 2425.35p 0 2544.35p 0 2547.35p 600u 2550.35p 0 2669.35p 0 2672.35p 600u 2675.35p 0 2794.35p 0 2797.35p 600u 2800.35p 0 2919.35p 0 2922.35p 600u 2925.35p 0 3044.35p 0 3047.35p 600u 3050.35p 0 3169.35p 0 3172.35p 600u 3175.35p 0 3294.35p 0 3297.35p 600u 3300.35p 0 3419.35p 0 3422.35p 600u 3425.35p 0 3544.35p 0 3547.35p 600u 3550.35p 0 3669.35p 0 3672.35p 600u 3675.35p 0 3794.35p 0 3797.35p 600u 3800.35p 0 3919.35p 0 3922.35p 600u 3925.35p 0 4044.35p 0 4047.35p 600u 4050.35p 0)
XSr2 THmitll_DCSFQ-PTLTX nr2 r2_i
* r3 = 00000000000000001111111111111111
I_r3 0 nr3 PWL(0 0 2169.35p 0 2172.35p 600u 2175.35p 0 2294.35p 0 2297.35p 600u 2300.35p 0 2419.35p 0 2422.35p 600u 2425.35p 0 2544.35p 0 2547.35p 600u 2550.35p 0 2669.35p 0 2672.35p 600u 2675.35p 0 2794.35p 0 2797.35p 600u 2800.35p 0 2919.35p 0 2922.35p 600u 2925.35p 0 3044.35p 0 3047.35p 600u 3050.35p 0 3169.35p 0 3172.35p 600u 3175.35p 0 3294.35p 0 3297.35p 600u 3300.35p 0 3419.35p 0 3422.35p 600u 3425.35p 0 3544.35p 0 3547.35p 600u 3550.35p 0 3669.35p 0 3672.35p 600u 3675.35p 0 3794.35p 0 3797.35p 600u 3800.35p 0 3919.35p 0 3922.35p 600u 3925.35p 0 4044.35p 0 4047.35p 600u 4050.35p 0)
XSr3 THmitll_DCSFQ-PTLTX nr3 r3_i
* r4 = 00000000111111110000000011111111
I_r4 0 nr4 PWL(0 0 1169.35p 0 1172.35p 600u 1175.35p 0 1294.35p 0 1297.35p 600u 1300.35p 0 1419.35p 0 1422.35p 600u 1425.35p 0 1544.35p 0 1547.35p 600u 1550.35p 0 1669.35p 0 1672.35p 600u 1675.35p 0 1794.35p 0 1797.35p 600u 1800.35p 0 1919.35p 0 1922.35p 600u 1925.35p 0 2044.35p 0 2047.35p 600u 2050.35p 0 3169.35p 0 3172.35p 600u 3175.35p 0 3294.35p 0 3297.35p 600u 3300.35p 0 3419.35p 0 3422.35p 600u 3425.35p 0 3544.35p 0 3547.35p 600u 3550.35p 0 3669.35p 0 3672.35p 600u 3675.35p 0 3794.35p 0 3797.35p 600u 3800.35p 0 3919.35p 0 3922.35p 600u 3925.35p 0 4044.35p 0 4047.35p 600u 4050.35p 0)
XSr4 THmitll_DCSFQ-PTLTX nr4 r4_i
* r5 = 00001111000011110000111100001111
I_r5 0 nr5 PWL(0 0 669.35p 0 672.35p 600u 675.35p 0 794.35p 0 797.35p 600u 800.35p 0 919.35p 0 922.35p 600u 925.35p 0 1044.35p 0 1047.35p 600u 1050.35p 0 1669.35p 0 1672.35p 600u 1675.35p 0 1794.35p 0 1797.35p 600u 1800.35p 0 1919.35p 0 1922.35p 600u 1925.35p 0 2044.35p 0 2047.35p 600u 2050.35p 0 2669.35p 0 2672.35p 600u 2675.35p 0 2794.35p 0 2797.35p 600u 2800.35p 0 2919.35p 0 2922.35p 600u 2925.35p 0 3044.35p 0 3047.35p 600u 3050.35p 0 3669.35p 0 3672.35p 600u 3675.35p 0 3794.35p 0 3797.35p 600u 3800.35p 0 3919.35p 0 3922.35p 600u 3925.35p 0 4044.35p 0 4047.35p 600u 4050.35p 0)
XSr5 THmitll_DCSFQ-PTLTX nr5 r5_i
* r6 = 00110011001100110011001100110011
I_r6 0 nr6 PWL(0 0 419.35p 0 422.35p 600u 425.35p 0 544.35p 0 547.35p 600u 550.35p 0 919.35p 0 922.35p 600u 925.35p 0 1044.35p 0 1047.35p 600u 1050.35p 0 1419.35p 0 1422.35p 600u 1425.35p 0 1544.35p 0 1547.35p 600u 1550.35p 0 1919.35p 0 1922.35p 600u 1925.35p 0 2044.35p 0 2047.35p 600u 2050.35p 0 2419.35p 0 2422.35p 600u 2425.35p 0 2544.35p 0 2547.35p 600u 2550.35p 0 2919.35p 0 2922.35p 600u 2925.35p 0 3044.35p 0 3047.35p 600u 3050.35p 0 3419.35p 0 3422.35p 600u 3425.35p 0 3544.35p 0 3547.35p 600u 3550.35p 0 3919.35p 0 3922.35p 600u 3925.35p 0 4044.35p 0 4047.35p 600u 4050.35p 0)
XSr6 THmitll_DCSFQ-PTLTX nr6 r6_i
* r7 = 01010101010101010101010101010101
I_r7 0 nr7 PWL(0 0 294.35p 0 297.35p 600u 300.35p 0 544.35p 0 547.35p 600u 550.35p 0 794.35p 0 797.35p 600u 800.35p 0 1044.35p 0 1047.35p 600u 1050.35p 0 1294.35p 0 1297.35p 600u 1300.35p 0 1544.35p 0 1547.35p 600u 1550.35p 0 1794.35p 0 1797.35p 600u 1800.35p 0 2044.35p 0 2047.35p 600u 2050.35p 0 2294.35p 0 2297.35p 600u 2300.35p 0 2544.35p 0 2547.35p 600u 2550.35p 0 2794.35p 0 2797.35p 600u 2800.35p 0 3044.35p 0 3047.35p 600u 3050.35p 0 3294.35p 0 3297.35p 600u 3300.35p 0 3544.35p 0 3547.35p 600u 3550.35p 0 3794.35p 0 3797.35p 600u 3800.35p 0 4044.35p 0 4047.35p 600u 4050.35p 0)
XSr7 THmitll_DCSFQ-PTLTX nr7 r7_i

* ===== readout =====
XRs1__spl_10 THmitll_PTLRX-SFQDC s1__spl_10_o rs1__spl_10
Rs1__spl_10 rs1__spl_10 0 2
XRs2__spl_12 THmitll_PTLRX-SFQDC s2__spl_12_o rs2__spl_12
Rs2__spl_12 rs2__spl_12 0 2
XRs3__spl_8 THmitll_PTLRX-SFQDC s3__spl_8_o rs3__spl_8
Rs3__spl_8 rs3__spl_8 0 2
XRerr THmitll_PTLRX-SFQDC err_o rerr
Rerr rerr 0 2

* ===== analysis =====
* output watch 466 ps, decode window 591 ps (max depth 4, periods 3, travel 41 ps)
.tran 0.2p 4566p 0
.print v(clk_i) v(r1_i) v(r2_i) v(r3_i) v(r4_i) v(r5_i) v(r6_i) v(r7_i) v(s1__spl_10_o) v(s2__spl_12_o) v(s3__spl_8_o) v(err_o)
.end
