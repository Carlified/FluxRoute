* --- subcircuit includes ---
.include lib/PTL_M3.cir
.include lib/PTLCAP_M1.cir
.include lib/PTL_M1.cir
.include lib/VIA_M1_M3_STRAIGHT.cir
.include lib/BEND_PTL_M1.cir
.include lib/PTLCAP_M3.cir
.include lib/VIA_M1_M3_BENDS.cir
.include lib/BEND_PTL_M3.cir
.include lib/SPLIT_M5_3.cir
.include lib/SPLIT_M5_3_S.cir
.include lib/SPLIT_M5_3_WE.cir
.include lib/SPLIT_M5_4_SN.cir
.include lib/VIA_M1_M3_BENDN.cir
.include lib/THmitll_AND2T_v3p0_extracted.cir
.include lib/THmitll_XORT_v3p0_extracted.cir
.include lib/THmitll_JTLT_v3p0_extracted.cir
.include lib/THmitll_SPLITT_v3p0_extracted.cir
.include lib/THmitll_DFFT_v3p0_extracted.cir

* mult_2x2 - SPICE netlist (flat)

* clock map: model=23 clock=34 clknet=12 clksig=12
Xn8_t0 n8_i n8_1 PTLCAP_M1
Xn8_t1 n8_1 n8_2 PTL_M1
Xn8_t2 n8_2 n8_3 PTL_M1
Xn8_t3 n8_3 n8_4 BEND_PTL_M1
Xn8_t4 n8_4 n8_o PTLCAP_M1
Xn1_t0 n1_i n1_1 PTLCAP_M1
Xn1_t1 n1_1 n1_2 PTL_M1
Xn1_t2 n1_2 n1_3 PTL_M1
Xn1_t3 n1_3 n1_4 BEND_PTL_M1
Xn1_t4 n1_4 n1_o PTLCAP_M1
Xn4__ff_1_t0 n4__ff_1_i n4__ff_1_1 PTLCAP_M1
Xn4__ff_1_t1 n4__ff_1_1 n4__ff_1_2 BEND_PTL_M1
Xn4__ff_1_t2 n4__ff_1_2 n4__ff_1_3 PTL_M1
Xn4__ff_1_t3 n4__ff_1_3 n4__ff_1_4 PTL_M1
Xn4__ff_1_t4 n4__ff_1_4 n4__ff_1_5 PTL_M1
Xn4__ff_1_t5 n4__ff_1_5 n4__ff_1_6 PTL_M1
Xn4__ff_1_t6 n4__ff_1_6 n4__ff_1_7 PTL_M1
Xn4__ff_1_t7 n4__ff_1_7 n4__ff_1_8 BEND_PTL_M1
Xn4__ff_1_t8 n4__ff_1_8 n4__ff_1_o PTLCAP_M1
Xn5_t0 n5_i n5_1 PTLCAP_M1
Xn5_t1 n5_1 n5_2 PTL_M1
Xn5_t2 n5_2 n5_3 PTL_M1
Xn5_t3 n5_3 n5_4 BEND_PTL_M1
Xn5_t4 n5_4 n5_5 PTL_M1
Xn5_t5 n5_5 n5_6 PTL_M1
Xn5_t6 n5_6 n5_7 PTL_M1
Xn5_t7 n5_7 n5_o PTLCAP_M1
Xclk_row_3__spl_6_t0 clk_row_3__spl_6_i clk_row_3__spl_6_1 PTLCAP_M1
Xclk_row_3__spl_6_t1 clk_row_3__spl_6_1 clk_row_3__spl_6_2 PTL_M1
Xclk_row_3__spl_6_t2 clk_row_3__spl_6_2 clk_row_3__spl_6_3 PTL_M1
Xclk_row_3__spl_6_t3 clk_row_3__spl_6_3 clk_row_3__spl_6_4 PTL_M1
Xclk_row_3__spl_6_t4 clk_row_3__spl_6_4 clk_row_3__spl_6_5 PTL_M1
Xclk_row_3__spl_6_t5 clk_row_3__spl_6_5 clk_row_3__spl_6_6 PTL_M1
Xclk_row_3__spl_6_t6 clk_row_3__spl_6_6 clk_row_3__spl_6_7 PTL_M1
Xclk_row_3__spl_6_t7 clk_row_3__spl_6_7 clk_row_3__spl_6_o PTLCAP_M1
Xclk_row_1__spl_1_t0 clk_row_1__spl_1_i clk_row_1__spl_1_1 PTLCAP_M1
Xclk_row_1__spl_1_t1 clk_row_1__spl_1_1 clk_row_1__spl_1_2 PTL_M1
Xclk_row_1__spl_1_t2 clk_row_1__spl_1_2 clk_row_1__spl_1_3 BEND_PTL_M1
Xclk_row_1__spl_1_t3 clk_row_1__spl_1_3 clk_row_1__spl_1_4 PTL_M1
Xclk_row_1__spl_1_t4 clk_row_1__spl_1_4 clk_row_1__spl_1_5 PTL_M1
Xclk_row_1__spl_1_t5 clk_row_1__spl_1_5 clk_row_1__spl_1_6 PTL_M1
Xclk_row_1__spl_1_t6 clk_row_1__spl_1_6 clk_row_1__spl_1_7 PTL_M1
Xclk_row_1__spl_1_t7 clk_row_1__spl_1_7 clk_row_1__spl_1_o PTLCAP_M1
Xclk_row_1__spl_6_t0 clk_row_1__spl_6_i clk_row_1__spl_6_1 PTLCAP_M1
Xclk_row_1__spl_6_t1 clk_row_1__spl_6_1 clk_row_1__spl_6_2 PTL_M1
Xclk_row_1__spl_6_t2 clk_row_1__spl_6_2 clk_row_1__spl_6_3 PTL_M1
Xclk_row_1__spl_6_t3 clk_row_1__spl_6_3 clk_row_1__spl_6_4 PTL_M1
Xclk_row_1__spl_6_t4 clk_row_1__spl_6_4 clk_row_1__spl_6_5 PTL_M1
Xclk_row_1__spl_6_t5 clk_row_1__spl_6_5 clk_row_1__spl_6_6 PTL_M1
Xclk_row_1__spl_6_t6 clk_row_1__spl_6_6 clk_row_1__spl_6_7 PTL_M1
Xclk_row_1__spl_6_t7 clk_row_1__spl_6_7 clk_row_1__spl_6_8 PTL_M1
Xclk_row_1__spl_6_t8 clk_row_1__spl_6_8 clk_row_1__spl_6_o PTLCAP_M1
Xclk_row_1__spl_4_t0 clk_row_1__spl_4_i clk_row_1__spl_4_1 PTLCAP_M1
Xclk_row_1__spl_4_t1 clk_row_1__spl_4_1 clk_row_1__spl_4_2 PTL_M1
Xclk_row_1__spl_4_t2 clk_row_1__spl_4_2 clk_row_1__spl_4_3 PTL_M1
Xclk_row_1__spl_4_t3 clk_row_1__spl_4_3 clk_row_1__spl_4_4 BEND_PTL_M1
Xclk_row_1__spl_4_t4 clk_row_1__spl_4_4 clk_row_1__spl_4_5 PTL_M1
Xclk_row_1__spl_4_t5 clk_row_1__spl_4_5 clk_row_1__spl_4_6 PTL_M1
Xclk_row_1__spl_4_t6 clk_row_1__spl_4_6 clk_row_1__spl_4_7 PTL_M1
Xclk_row_1__spl_4_t7 clk_row_1__spl_4_7 clk_row_1__spl_4_8 BEND_PTL_M1
Xclk_row_1__spl_4_t8 clk_row_1__spl_4_8 clk_row_1__spl_4_9 PTL_M1
Xclk_row_1__spl_4_t9 clk_row_1__spl_4_9 clk_row_1__spl_4_10 PTL_M1
Xclk_row_1__spl_4_t10 clk_row_1__spl_4_10 clk_row_1__spl_4_11 BEND_PTL_M1
Xclk_row_1__spl_4_t11 clk_row_1__spl_4_11 clk_row_1__spl_4_12 PTL_M1
Xclk_row_1__spl_4_t12 clk_row_1__spl_4_12 clk_row_1__spl_4_13 PTL_M1
Xclk_row_1__spl_4_t13 clk_row_1__spl_4_13 clk_row_1__spl_4_14 PTL_M1
Xclk_row_1__spl_4_t14 clk_row_1__spl_4_14 clk_row_1__spl_4_15 PTL_M1
Xclk_row_1__spl_4_t15 clk_row_1__spl_4_15 clk_row_1__spl_4_16 PTL_M1
Xclk_row_1__spl_4_t16 clk_row_1__spl_4_16 clk_row_1__spl_4_17 PTL_M1
Xclk_row_1__spl_4_t17 clk_row_1__spl_4_17 clk_row_1__spl_4_18 PTL_M1
Xclk_row_1__spl_4_t18 clk_row_1__spl_4_18 clk_row_1__spl_4_o PTLCAP_M1
Xclk_row_3__spl_3_t0 clk_row_3__spl_3_i clk_row_3__spl_3_1 PTLCAP_M1
Xclk_row_3__spl_3_t1 clk_row_3__spl_3_1 clk_row_3__spl_3_2 PTL_M1
Xclk_row_3__spl_3_t2 clk_row_3__spl_3_2 clk_row_3__spl_3_3 PTL_M1
Xclk_row_3__spl_3_t3 clk_row_3__spl_3_3 clk_row_3__spl_3_4 BEND_PTL_M1
Xclk_row_3__spl_3_t4 clk_row_3__spl_3_4 clk_row_3__spl_3_5 PTL_M1
Xclk_row_3__spl_3_t5 clk_row_3__spl_3_5 clk_row_3__spl_3_6 PTL_M1
Xclk_row_3__spl_3_t6 clk_row_3__spl_3_6 clk_row_3__spl_3_7 PTL_M1
Xclk_row_3__spl_3_t7 clk_row_3__spl_3_7 clk_row_3__spl_3_8 PTL_M1
Xclk_row_3__spl_3_t8 clk_row_3__spl_3_8 clk_row_3__spl_3_9 PTL_M1
Xclk_row_3__spl_3_t9 clk_row_3__spl_3_9 clk_row_3__spl_3_10 PTL_M1
Xclk_row_3__spl_3_t10 clk_row_3__spl_3_10 clk_row_3__spl_3_o PTLCAP_M1
Xclk_row_2__spl_5_t0 clk_row_2__spl_5_i clk_row_2__spl_5_1 PTLCAP_M1
Xclk_row_2__spl_5_t1 clk_row_2__spl_5_1 clk_row_2__spl_5_2 PTL_M1
Xclk_row_2__spl_5_t2 clk_row_2__spl_5_2 clk_row_2__spl_5_3 BEND_PTL_M1
Xclk_row_2__spl_5_t3 clk_row_2__spl_5_3 clk_row_2__spl_5_4 PTL_M1
Xclk_row_2__spl_5_t4 clk_row_2__spl_5_4 clk_row_2__spl_5_5 PTL_M1
Xclk_row_2__spl_5_t5 clk_row_2__spl_5_5 clk_row_2__spl_5_6 PTL_M1
Xclk_row_2__spl_5_t6 clk_row_2__spl_5_6 clk_row_2__spl_5_7 PTL_M1
Xclk_row_2__spl_5_t7 clk_row_2__spl_5_7 clk_row_2__spl_5_8 PTL_M1
Xclk_row_2__spl_5_t8 clk_row_2__spl_5_8 clk_row_2__spl_5_9 PTL_M1
Xclk_row_2__spl_5_t9 clk_row_2__spl_5_9 clk_row_2__spl_5_10 PTL_M1
Xclk_row_2__spl_5_t10 clk_row_2__spl_5_10 clk_row_2__spl_5_11 PTL_M1
Xclk_row_2__spl_5_t11 clk_row_2__spl_5_11 clk_row_2__spl_5_o PTLCAP_M1
Xclk_row_3__spl_2_t0 clk_row_3__spl_2_i clk_row_3__spl_2_1 PTLCAP_M1
Xclk_row_3__spl_2_t1 clk_row_3__spl_2_1 clk_row_3__spl_2_2 PTL_M1
Xclk_row_3__spl_2_t2 clk_row_3__spl_2_2 clk_row_3__spl_2_3 PTL_M1
Xclk_row_3__spl_2_t3 clk_row_3__spl_2_3 clk_row_3__spl_2_4 BEND_PTL_M1
Xclk_row_3__spl_2_t4 clk_row_3__spl_2_4 clk_row_3__spl_2_5 PTL_M1
Xclk_row_3__spl_2_t5 clk_row_3__spl_2_5 clk_row_3__spl_2_6 PTL_M1
Xclk_row_3__spl_2_t6 clk_row_3__spl_2_6 clk_row_3__spl_2_7 PTL_M1
Xclk_row_3__spl_2_t7 clk_row_3__spl_2_7 clk_row_3__spl_2_8 PTL_M1
Xclk_row_3__spl_2_t8 clk_row_3__spl_2_8 clk_row_3__spl_2_9 PTL_M1
Xclk_row_3__spl_2_t9 clk_row_3__spl_2_9 clk_row_3__spl_2_10 PTL_M1
Xclk_row_3__spl_2_t10 clk_row_3__spl_2_10 clk_row_3__spl_2_11 PTL_M1
Xclk_row_3__spl_2_t11 clk_row_3__spl_2_11 clk_row_3__spl_2_o PTLCAP_M1
Xclk_row_3__spl_4_t0 clk_row_3__spl_4_i clk_row_3__spl_4_1 PTLCAP_M1
Xclk_row_3__spl_4_t1 clk_row_3__spl_4_1 clk_row_3__spl_4_2 PTL_M1
Xclk_row_3__spl_4_t2 clk_row_3__spl_4_2 clk_row_3__spl_4_3 PTL_M1
Xclk_row_3__spl_4_t3 clk_row_3__spl_4_3 clk_row_3__spl_4_4 PTL_M1
Xclk_row_3__spl_4_t4 clk_row_3__spl_4_4 clk_row_3__spl_4_5 PTL_M1
Xclk_row_3__spl_4_t5 clk_row_3__spl_4_5 clk_row_3__spl_4_6 PTL_M1
Xclk_row_3__spl_4_t6 clk_row_3__spl_4_6 clk_row_3__spl_4_7 PTL_M1
Xclk_row_3__spl_4_t7 clk_row_3__spl_4_7 clk_row_3__spl_4_8 PTL_M1
Xclk_row_3__spl_4_t8 clk_row_3__spl_4_8 clk_row_3__spl_4_9 BEND_PTL_M1
Xclk_row_3__spl_4_t9 clk_row_3__spl_4_9 clk_row_3__spl_4_10 PTL_M1
Xclk_row_3__spl_4_t10 clk_row_3__spl_4_10 clk_row_3__spl_4_11 PTL_M1
Xclk_row_3__spl_4_t11 clk_row_3__spl_4_11 clk_row_3__spl_4_12 PTL_M1
Xclk_row_3__spl_4_t12 clk_row_3__spl_4_12 clk_row_3__spl_4_o PTLCAP_M1
Xn6_t0 n6_i n6_1 PTLCAP_M1
Xn6_t1 n6_1 n6_2 PTL_M1
Xn6_t2 n6_2 n6_3 PTL_M1
Xn6_t3 n6_3 n6_4 PTL_M1
Xn6_t4 n6_4 n6_5 PTL_M1
Xn6_t5 n6_5 n6_6 PTL_M1
Xn6_t6 n6_6 n6_7 PTL_M1
Xn6_t7 n6_7 n6_8 PTL_M1
Xn6_t8 n6_8 n6_9 PTL_M1
Xn6_t9 n6_9 n6_10 BEND_PTL_M1
Xn6_t10 n6_10 n6_11 PTL_M1
Xn6_t11 n6_11 n6_12 PTL_M1
Xn6_t12 n6_12 n6_13 PTL_M1
Xn6_t13 n6_13 n6_o PTLCAP_M1
Xclk_row_2__spl_1_t0 clk_row_2__spl_1_i clk_row_2__spl_1_1 PTLCAP_M1
Xclk_row_2__spl_1_t1 clk_row_2__spl_1_1 clk_row_2__spl_1_2 PTL_M1
Xclk_row_2__spl_1_t2 clk_row_2__spl_1_2 clk_row_2__spl_1_3 PTL_M1
Xclk_row_2__spl_1_t3 clk_row_2__spl_1_3 clk_row_2__spl_1_4 PTL_M1
Xclk_row_2__spl_1_t4 clk_row_2__spl_1_4 clk_row_2__spl_1_5 PTL_M1
Xclk_row_2__spl_1_t5 clk_row_2__spl_1_5 clk_row_2__spl_1_6 PTL_M1
Xclk_row_2__spl_1_t6 clk_row_2__spl_1_6 clk_row_2__spl_1_7 PTL_M1
Xclk_row_2__spl_1_t7 clk_row_2__spl_1_7 clk_row_2__spl_1_8 PTL_M1
Xclk_row_2__spl_1_t8 clk_row_2__spl_1_8 clk_row_2__spl_1_9 BEND_PTL_M1
Xclk_row_2__spl_1_t9 clk_row_2__spl_1_9 clk_row_2__spl_1_10 PTL_M1
Xclk_row_2__spl_1_t10 clk_row_2__spl_1_10 clk_row_2__spl_1_11 PTL_M1
Xclk_row_2__spl_1_t11 clk_row_2__spl_1_11 clk_row_2__spl_1_12 PTL_M1
Xclk_row_2__spl_1_t12 clk_row_2__spl_1_12 clk_row_2__spl_1_13 PTL_M1
Xclk_row_2__spl_1_t13 clk_row_2__spl_1_13 clk_row_2__spl_1_o PTLCAP_M1
Xclk_row_1__spl_2_t0 clk_row_1__spl_2_i clk_row_1__spl_2_1 PTLCAP_M1
Xclk_row_1__spl_2_t1 clk_row_1__spl_2_1 clk_row_1__spl_2_2 PTL_M1
Xclk_row_1__spl_2_t2 clk_row_1__spl_2_2 clk_row_1__spl_2_3 PTL_M1
Xclk_row_1__spl_2_t3 clk_row_1__spl_2_3 clk_row_1__spl_2_4 PTL_M1
Xclk_row_1__spl_2_t4 clk_row_1__spl_2_4 clk_row_1__spl_2_5 BEND_PTL_M1
Xclk_row_1__spl_2_t5 clk_row_1__spl_2_5 clk_row_1__spl_2_6 PTL_M1
Xclk_row_1__spl_2_t6 clk_row_1__spl_2_6 clk_row_1__spl_2_7 PTL_M1
Xclk_row_1__spl_2_t7 clk_row_1__spl_2_7 clk_row_1__spl_2_8 PTL_M1
Xclk_row_1__spl_2_t8 clk_row_1__spl_2_8 clk_row_1__spl_2_9 PTL_M1
Xclk_row_1__spl_2_t9 clk_row_1__spl_2_9 clk_row_1__spl_2_10 PTL_M1
Xclk_row_1__spl_2_t10 clk_row_1__spl_2_10 clk_row_1__spl_2_11 PTL_M1
Xclk_row_1__spl_2_t11 clk_row_1__spl_2_11 clk_row_1__spl_2_12 PTL_M1
Xclk_row_1__spl_2_t12 clk_row_1__spl_2_12 clk_row_1__spl_2_13 PTL_M1
Xclk_row_1__spl_2_t13 clk_row_1__spl_2_13 clk_row_1__spl_2_o PTLCAP_M1
Xclk_row_3__spl_5_t0 clk_row_3__spl_5_i clk_row_3__spl_5_1 PTLCAP_M1
Xclk_row_3__spl_5_t1 clk_row_3__spl_5_1 clk_row_3__spl_5_2 PTL_M1
Xclk_row_3__spl_5_t2 clk_row_3__spl_5_2 clk_row_3__spl_5_3 BEND_PTL_M1
Xclk_row_3__spl_5_t3 clk_row_3__spl_5_3 clk_row_3__spl_5_4 PTL_M1
Xclk_row_3__spl_5_t4 clk_row_3__spl_5_4 clk_row_3__spl_5_5 PTL_M1
Xclk_row_3__spl_5_t5 clk_row_3__spl_5_5 clk_row_3__spl_5_6 PTL_M1
Xclk_row_3__spl_5_t6 clk_row_3__spl_5_6 clk_row_3__spl_5_7 PTL_M1
Xclk_row_3__spl_5_t7 clk_row_3__spl_5_7 clk_row_3__spl_5_8 PTL_M1
Xclk_row_3__spl_5_t8 clk_row_3__spl_5_8 clk_row_3__spl_5_9 PTL_M1
Xclk_row_3__spl_5_t9 clk_row_3__spl_5_9 clk_row_3__spl_5_10 PTL_M1
Xclk_row_3__spl_5_t10 clk_row_3__spl_5_10 clk_row_3__spl_5_11 PTL_M1
Xclk_row_3__spl_5_t11 clk_row_3__spl_5_11 clk_row_3__spl_5_12 BEND_PTL_M1
Xclk_row_3__spl_5_t12 clk_row_3__spl_5_12 clk_row_3__spl_5_13 PTL_M1
Xclk_row_3__spl_5_t13 clk_row_3__spl_5_13 clk_row_3__spl_5_14 PTL_M1
Xclk_row_3__spl_5_t14 clk_row_3__spl_5_14 clk_row_3__spl_5_15 PTL_M1
Xclk_row_3__spl_5_t15 clk_row_3__spl_5_15 clk_row_3__spl_5_16 PTL_M1
Xclk_row_3__spl_5_t16 clk_row_3__spl_5_16 clk_row_3__spl_5_17 PTL_M1
Xclk_row_3__spl_5_t17 clk_row_3__spl_5_17 clk_row_3__spl_5_18 PTL_M1
Xclk_row_3__spl_5_t18 clk_row_3__spl_5_18 clk_row_3__spl_5_19 PTL_M1
Xclk_row_3__spl_5_t19 clk_row_3__spl_5_19 clk_row_3__spl_5_20 BEND_PTL_M1
Xclk_row_3__spl_5_t20 clk_row_3__spl_5_20 clk_row_3__spl_5_o PTLCAP_M1
Xclk_row_2__spl_3_t0 clk_row_2__spl_3_i clk_row_2__spl_3_1 PTLCAP_M1
Xclk_row_2__spl_3_t1 clk_row_2__spl_3_1 clk_row_2__spl_3_2 PTL_M1
Xclk_row_2__spl_3_t2 clk_row_2__spl_3_2 clk_row_2__spl_3_3 PTL_M1
Xclk_row_2__spl_3_t3 clk_row_2__spl_3_3 clk_row_2__spl_3_4 PTL_M1
Xclk_row_2__spl_3_t4 clk_row_2__spl_3_4 clk_row_2__spl_3_5 PTL_M1
Xclk_row_2__spl_3_t5 clk_row_2__spl_3_5 clk_row_2__spl_3_6 PTL_M1
Xclk_row_2__spl_3_t6 clk_row_2__spl_3_6 clk_row_2__spl_3_7 PTL_M1
Xclk_row_2__spl_3_t7 clk_row_2__spl_3_7 clk_row_2__spl_3_8 BEND_PTL_M1
Xclk_row_2__spl_3_t8 clk_row_2__spl_3_8 clk_row_2__spl_3_9 PTL_M1
Xclk_row_2__spl_3_t9 clk_row_2__spl_3_9 clk_row_2__spl_3_10 PTL_M1
Xclk_row_2__spl_3_t10 clk_row_2__spl_3_10 clk_row_2__spl_3_11 PTL_M1
Xclk_row_2__spl_3_t11 clk_row_2__spl_3_11 clk_row_2__spl_3_12 PTL_M1
Xclk_row_2__spl_3_t12 clk_row_2__spl_3_12 clk_row_2__spl_3_13 PTL_M1
Xclk_row_2__spl_3_t13 clk_row_2__spl_3_13 clk_row_2__spl_3_14 PTL_M1
Xclk_row_2__spl_3_t14 clk_row_2__spl_3_14 clk_row_2__spl_3_15 PTL_M1
Xclk_row_2__spl_3_t15 clk_row_2__spl_3_15 clk_row_2__spl_3_o PTLCAP_M1
Xn3_t0 n3_i n3_1 PTLCAP_M1
Xn3_t1 n3_1 n3_2 PTL_M1
Xn3_t2 n3_2 n3_3 PTL_M1
Xn3_t3 n3_3 n3_4 BEND_PTL_M1
Xn3_t4 n3_4 n3_5 PTL_M1
Xn3_t5 n3_5 n3_6 PTL_M1
Xn3_t6 n3_6 n3_7 PTL_M1
Xn3_t7 n3_7 n3_8 PTL_M1
Xn3_t8 n3_8 n3_9 PTL_M1
Xn3_t9 n3_9 n3_10 PTL_M1
Xn3_t10 n3_10 n3_11 PTL_M1
Xn3_t11 n3_11 n3_12 PTL_M1
Xn3_t12 n3_12 n3_13 PTL_M1
Xn3_t13 n3_13 n3_14 PTL_M1
Xn3_t14 n3_14 n3_15 PTL_M1
Xn3_t15 n3_15 n3_16 BEND_PTL_M1
Xn3_t16 n3_16 n3_o PTLCAP_M1
Xclk_row_2__spl_6_t0 clk_row_2__spl_6_i clk_row_2__spl_6_1 PTLCAP_M1
Xclk_row_2__spl_6_t1 clk_row_2__spl_6_1 clk_row_2__spl_6_2 PTL_M1
Xclk_row_2__spl_6_t2 clk_row_2__spl_6_2 clk_row_2__spl_6_3 PTL_M1
Xclk_row_2__spl_6_t3 clk_row_2__spl_6_3 clk_row_2__spl_6_4 PTL_M1
Xclk_row_2__spl_6_t4 clk_row_2__spl_6_4 clk_row_2__spl_6_5 PTL_M1
Xclk_row_2__spl_6_t5 clk_row_2__spl_6_5 clk_row_2__spl_6_6 PTL_M1
Xclk_row_2__spl_6_t6 clk_row_2__spl_6_6 clk_row_2__spl_6_7 PTL_M1
Xclk_row_2__spl_6_t7 clk_row_2__spl_6_7 clk_row_2__spl_6_8 PTL_M1
Xclk_row_2__spl_6_t8 clk_row_2__spl_6_8 clk_row_2__spl_6_9 BEND_PTL_M1
Xclk_row_2__spl_6_t9 clk_row_2__spl_6_9 clk_row_2__spl_6_10 PTL_M1
Xclk_row_2__spl_6_t10 clk_row_2__spl_6_10 clk_row_2__spl_6_11 PTL_M1
Xclk_row_2__spl_6_t11 clk_row_2__spl_6_11 clk_row_2__spl_6_12 PTL_M1
Xclk_row_2__spl_6_t12 clk_row_2__spl_6_12 clk_row_2__spl_6_13 PTL_M1
Xclk_row_2__spl_6_t13 clk_row_2__spl_6_13 clk_row_2__spl_6_14 PTL_M1
Xclk_row_2__spl_6_t14 clk_row_2__spl_6_14 clk_row_2__spl_6_15 PTL_M1
Xclk_row_2__spl_6_t15 clk_row_2__spl_6_15 clk_row_2__spl_6_16 PTL_M1
Xclk_row_2__spl_6_t16 clk_row_2__spl_6_16 clk_row_2__spl_6_o PTLCAP_M1
Xb1_t0 b1_i b1_1 PTLCAP_M1
Xb1_t1 b1_1 b1_2 PTL_M1
Xb1_t2 b1_2 b1_3 PTL_M1
Xb1_t3 b1_3 b1_4 BEND_PTL_M1
Xb1_t4 b1_4 b1_5 PTL_M1
Xb1_t5 b1_5 b1_6 PTL_M1
Xb1_t6 b1_6 b1_7 PTL_M1
Xb1_t7 b1_7 b1_8 PTL_M1
Xb1_t8 b1_8 b1_9 PTL_M1
Xb1_t9 b1_9 b1_10 PTL_M1
Xb1_t10 b1_10 b1_11 PTL_M1
Xb1_t11 b1_11 b1_12 PTL_M1
Xb1_t12 b1_12 b1_13 PTL_M1
Xb1_t13 b1_13 b1_14 PTL_M1
Xb1_t14 b1_14 b1_15 PTL_M1
Xb1_t15 b1_15 b1_16 PTL_M1
Xb1_t16 b1_16 b1_o PTLCAP_M1
Xa0__spl_12_t0 a0__spl_12_i a0__spl_12_1 PTLCAP_M1
Xa0__spl_12_t1 a0__spl_12_1 a0__spl_12_2 PTL_M1
Xa0__spl_12_t2 a0__spl_12_2 a0__spl_12_3 PTL_M1
Xa0__spl_12_t3 a0__spl_12_3 a0__spl_12_4 BEND_PTL_M1
Xa0__spl_12_t4 a0__spl_12_4 a0__spl_12_5 PTL_M1
Xa0__spl_12_t5 a0__spl_12_5 a0__spl_12_6 PTL_M1
Xa0__spl_12_t6 a0__spl_12_6 a0__spl_12_7 PTL_M1
Xa0__spl_12_t7 a0__spl_12_7 a0__spl_12_8 PTL_M1
Xa0__spl_12_t8 a0__spl_12_8 a0__spl_12_9 PTL_M1
Xa0__spl_12_t9 a0__spl_12_9 a0__spl_12_10 PTL_M1
Xa0__spl_12_t10 a0__spl_12_10 a0__spl_12_11 PTL_M1
Xa0__spl_12_t11 a0__spl_12_11 a0__spl_12_12 PTL_M1
Xa0__spl_12_t12 a0__spl_12_12 a0__spl_12_13 PTL_M1
Xa0__spl_12_t13 a0__spl_12_13 a0__spl_12_14 PTL_M1
Xa0__spl_12_t14 a0__spl_12_14 a0__spl_12_15 PTL_M1
Xa0__spl_12_t15 a0__spl_12_15 a0__spl_12_16 PTL_M1
Xa0__spl_12_t16 a0__spl_12_16 a0__spl_12_17 PTL_M1
Xa0__spl_12_t17 a0__spl_12_17 a0__spl_12_o PTLCAP_M1
Xn4__spl_7__ff_2_t0 n4__spl_7__ff_2_i n4__spl_7__ff_2_1 PTLCAP_M1
Xn4__spl_7__ff_2_t1 n4__spl_7__ff_2_1 n4__spl_7__ff_2_2 PTL_M1
Xn4__spl_7__ff_2_t2 n4__spl_7__ff_2_2 n4__spl_7__ff_2_3 PTL_M1
Xn4__spl_7__ff_2_t3 n4__spl_7__ff_2_3 n4__spl_7__ff_2_4 BEND_PTL_M1
Xn4__spl_7__ff_2_t4 n4__spl_7__ff_2_4 n4__spl_7__ff_2_5 PTL_M1
Xn4__spl_7__ff_2_t5 n4__spl_7__ff_2_5 n4__spl_7__ff_2_6 PTL_M1
Xn4__spl_7__ff_2_t6 n4__spl_7__ff_2_6 n4__spl_7__ff_2_7 PTL_M1
Xn4__spl_7__ff_2_t7 n4__spl_7__ff_2_7 n4__spl_7__ff_2_8 PTL_M1
Xn4__spl_7__ff_2_t8 n4__spl_7__ff_2_8 n4__spl_7__ff_2_9 PTL_M1
Xn4__spl_7__ff_2_t9 n4__spl_7__ff_2_9 n4__spl_7__ff_2_10 PTL_M1
Xn4__spl_7__ff_2_t10 n4__spl_7__ff_2_10 n4__spl_7__ff_2_11 PTL_M1
Xn4__spl_7__ff_2_t11 n4__spl_7__ff_2_11 n4__spl_7__ff_2_12 BEND_PTL_M1
Xn4__spl_7__ff_2_t12 n4__spl_7__ff_2_12 n4__spl_7__ff_2_13 BEND_PTL_M1
Xn4__spl_7__ff_2_t13 n4__spl_7__ff_2_13 n4__spl_7__ff_2_14 PTL_M1
Xn4__spl_7__ff_2_t14 n4__spl_7__ff_2_14 n4__spl_7__ff_2_15 PTL_M1
Xn4__spl_7__ff_2_t15 n4__spl_7__ff_2_15 n4__spl_7__ff_2_16 PTL_M1
Xn4__spl_7__ff_2_t16 n4__spl_7__ff_2_16 n4__spl_7__ff_2_17 PTL_M1
Xn4__spl_7__ff_2_t17 n4__spl_7__ff_2_17 n4__spl_7__ff_2_18 PTL_M1
Xn4__spl_7__ff_2_t18 n4__spl_7__ff_2_18 n4__spl_7__ff_2_19 BEND_PTL_M1
Xn4__spl_7__ff_2_t19 n4__spl_7__ff_2_19 n4__spl_7__ff_2_20 PTL_M1
Xn4__spl_7__ff_2_t20 n4__spl_7__ff_2_20 n4__spl_7__ff_2_21 BEND_PTL_M1
Xn4__spl_7__ff_2_t21 n4__spl_7__ff_2_21 n4__spl_7__ff_2_o PTLCAP_M1
Xclk_row_2__spl_4_t0 clk_row_2__spl_4_i clk_row_2__spl_4_1 PTLCAP_M1
Xclk_row_2__spl_4_t1 clk_row_2__spl_4_1 clk_row_2__spl_4_2 PTL_M1
Xclk_row_2__spl_4_t2 clk_row_2__spl_4_2 clk_row_2__spl_4_3 PTL_M1
Xclk_row_2__spl_4_t3 clk_row_2__spl_4_3 clk_row_2__spl_4_4 PTL_M1
Xclk_row_2__spl_4_t4 clk_row_2__spl_4_4 clk_row_2__spl_4_5 PTL_M1
Xclk_row_2__spl_4_t5 clk_row_2__spl_4_5 clk_row_2__spl_4_6 PTL_M1
Xclk_row_2__spl_4_t6 clk_row_2__spl_4_6 clk_row_2__spl_4_7 PTL_M1
Xclk_row_2__spl_4_t7 clk_row_2__spl_4_7 clk_row_2__spl_4_8 BEND_PTL_M1
Xclk_row_2__spl_4_t8 clk_row_2__spl_4_8 clk_row_2__spl_4_9 PTL_M1
Xclk_row_2__spl_4_t9 clk_row_2__spl_4_9 clk_row_2__spl_4_10 PTL_M1
Xclk_row_2__spl_4_t10 clk_row_2__spl_4_10 clk_row_2__spl_4_11 PTL_M1
Xclk_row_2__spl_4_t11 clk_row_2__spl_4_11 clk_row_2__spl_4_12 PTL_M1
Xclk_row_2__spl_4_t12 clk_row_2__spl_4_12 clk_row_2__spl_4_13 PTL_M1
Xclk_row_2__spl_4_t13 clk_row_2__spl_4_13 clk_row_2__spl_4_14 PTL_M1
Xclk_row_2__spl_4_t14 clk_row_2__spl_4_14 clk_row_2__spl_4_15 PTL_M1
Xclk_row_2__spl_4_t15 clk_row_2__spl_4_15 clk_row_2__spl_4_16 PTL_M1
Xclk_row_2__spl_4_t16 clk_row_2__spl_4_16 clk_row_2__spl_4_17 BEND_PTL_M1
Xclk_row_2__spl_4_t17 clk_row_2__spl_4_17 clk_row_2__spl_4_18 PTL_M1
Xclk_row_2__spl_4_t18 clk_row_2__spl_4_18 clk_row_2__spl_4_19 PTL_M1
Xclk_row_2__spl_4_t19 clk_row_2__spl_4_19 clk_row_2__spl_4_20 PTL_M1
Xclk_row_2__spl_4_t20 clk_row_2__spl_4_20 clk_row_2__spl_4_21 PTL_M1
Xclk_row_2__spl_4_t21 clk_row_2__spl_4_21 clk_row_2__spl_4_22 PTL_M1
Xclk_row_2__spl_4_t22 clk_row_2__spl_4_22 clk_row_2__spl_4_23 PTL_M1
Xclk_row_2__spl_4_t23 clk_row_2__spl_4_23 clk_row_2__spl_4_24 BEND_PTL_M1
Xclk_row_2__spl_4_t24 clk_row_2__spl_4_24 clk_row_2__spl_4_25 PTL_M1
Xclk_row_2__spl_4_t25 clk_row_2__spl_4_25 clk_row_2__spl_4_26 PTL_M1
Xclk_row_2__spl_4_t26 clk_row_2__spl_4_26 clk_row_2__spl_4_27 PTL_M1
Xclk_row_2__spl_4_t27 clk_row_2__spl_4_27 clk_row_2__spl_4_28 PTL_M1
Xclk_row_2__spl_4_t28 clk_row_2__spl_4_28 clk_row_2__spl_4_29 BEND_PTL_M1
Xclk_row_2__spl_4_t29 clk_row_2__spl_4_29 clk_row_2__spl_4_o PTLCAP_M1
Xn3__spl_9_t0 n3__spl_9_i n3__spl_9_1 PTLCAP_M1
Xn3__spl_9_t1 n3__spl_9_1 n3__spl_9_2 PTL_M1
Xn3__spl_9_t2 n3__spl_9_2 n3__spl_9_3 BEND_PTL_M1
Xn3__spl_9_t3 n3__spl_9_3 n3__spl_9_4 PTL_M1
Xn3__spl_9_t4 n3__spl_9_4 n3__spl_9_5 PTL_M1
Xn3__spl_9_t5 n3__spl_9_5 n3__spl_9_6 PTL_M1
Xn3__spl_9_t6 n3__spl_9_6 n3__spl_9_7 PTL_M1
Xn3__spl_9_t7 n3__spl_9_7 n3__spl_9_8 PTL_M1
Xn3__spl_9_t8 n3__spl_9_8 n3__spl_9_9 PTL_M1
Xn3__spl_9_t9 n3__spl_9_9 n3__spl_9_10 PTL_M1
Xn3__spl_9_t10 n3__spl_9_10 n3__spl_9_11 PTL_M1
Xn3__spl_9_t11 n3__spl_9_11 n3__spl_9_12 PTL_M1
Xn3__spl_9_t12 n3__spl_9_12 n3__spl_9_13 PTL_M1
Xn3__spl_9_t13 n3__spl_9_13 n3__spl_9_14 PTL_M1
Xn3__spl_9_t14 n3__spl_9_14 n3__spl_9_15 PTL_M1
Xn3__spl_9_t15 n3__spl_9_15 n3__spl_9_16 PTL_M1
Xn3__spl_9_t16 n3__spl_9_16 n3__spl_9_17 PTL_M1
Xn3__spl_9_t17 n3__spl_9_17 n3__spl_9_o PTLCAP_M1
Xclk_row_2__spl_2_t0 clk_row_2__spl_2_i clk_row_2__spl_2_1 PTLCAP_M1
Xclk_row_2__spl_2_t1 clk_row_2__spl_2_1 clk_row_2__spl_2_2 PTL_M1
Xclk_row_2__spl_2_t2 clk_row_2__spl_2_2 clk_row_2__spl_2_3 PTL_M1
Xclk_row_2__spl_2_t3 clk_row_2__spl_2_3 clk_row_2__spl_2_4 PTL_M1
Xclk_row_2__spl_2_t4 clk_row_2__spl_2_4 clk_row_2__spl_2_5 PTL_M1
Xclk_row_2__spl_2_t5 clk_row_2__spl_2_5 clk_row_2__spl_2_6 PTL_M1
Xclk_row_2__spl_2_t6 clk_row_2__spl_2_6 clk_row_2__spl_2_7 PTL_M1
Xclk_row_2__spl_2_t7 clk_row_2__spl_2_7 clk_row_2__spl_2_8 PTL_M1
Xclk_row_2__spl_2_t8 clk_row_2__spl_2_8 clk_row_2__spl_2_9 BEND_PTL_M1
Xclk_row_2__spl_2_t9 clk_row_2__spl_2_9 clk_row_2__spl_2_10 PTL_M1
Xclk_row_2__spl_2_t10 clk_row_2__spl_2_10 clk_row_2__spl_2_11 PTL_M1
Xclk_row_2__spl_2_t11 clk_row_2__spl_2_11 clk_row_2__spl_2_12 PTL_M1
Xclk_row_2__spl_2_t12 clk_row_2__spl_2_12 clk_row_2__spl_2_13 PTL_M1
Xclk_row_2__spl_2_t13 clk_row_2__spl_2_13 clk_row_2__spl_2_14 PTL_M1
Xclk_row_2__spl_2_t14 clk_row_2__spl_2_14 clk_row_2__spl_2_15 PTL_M1
Xclk_row_2__spl_2_t15 clk_row_2__spl_2_15 clk_row_2__spl_2_16 PTL_M1
Xclk_row_2__spl_2_t16 clk_row_2__spl_2_16 clk_row_2__spl_2_17 PTL_M1
Xclk_row_2__spl_2_t17 clk_row_2__spl_2_17 clk_row_2__spl_2_18 PTL_M1
Xclk_row_2__spl_2_t18 clk_row_2__spl_2_18 clk_row_2__spl_2_19 PTL_M1
Xclk_row_2__spl_2_t19 clk_row_2__spl_2_19 clk_row_2__spl_2_20 PTL_M1
Xclk_row_2__spl_2_t20 clk_row_2__spl_2_20 clk_row_2__spl_2_21 BEND_PTL_M1
Xclk_row_2__spl_2_t21 clk_row_2__spl_2_21 clk_row_2__spl_2_22 PTL_M1
Xclk_row_2__spl_2_t22 clk_row_2__spl_2_22 clk_row_2__spl_2_23 PTL_M1
Xclk_row_2__spl_2_t23 clk_row_2__spl_2_23 clk_row_2__spl_2_24 PTL_M1
Xclk_row_2__spl_2_t24 clk_row_2__spl_2_24 clk_row_2__spl_2_25 PTL_M1
Xclk_row_2__spl_2_t25 clk_row_2__spl_2_25 clk_row_2__spl_2_26 PTL_M1
Xclk_row_2__spl_2_t26 clk_row_2__spl_2_26 clk_row_2__spl_2_27 PTL_M1
Xclk_row_2__spl_2_t27 clk_row_2__spl_2_27 clk_row_2__spl_2_28 PTL_M1
Xclk_row_2__spl_2_t28 clk_row_2__spl_2_28 clk_row_2__spl_2_29 PTL_M1
Xclk_row_2__spl_2_t29 clk_row_2__spl_2_29 clk_row_2__spl_2_30 PTL_M1
Xclk_row_2__spl_2_t30 clk_row_2__spl_2_30 clk_row_2__spl_2_31 PTL_M1
Xclk_row_2__spl_2_t31 clk_row_2__spl_2_31 clk_row_2__spl_2_32 PTL_M1
Xclk_row_2__spl_2_t32 clk_row_2__spl_2_32 clk_row_2__spl_2_33 PTL_M1
Xclk_row_2__spl_2_t33 clk_row_2__spl_2_33 clk_row_2__spl_2_34 BEND_PTL_M1
Xclk_row_2__spl_2_t34 clk_row_2__spl_2_34 clk_row_2__spl_2_35 PTL_M1
Xclk_row_2__spl_2_t35 clk_row_2__spl_2_35 clk_row_2__spl_2_36 PTL_M1
Xclk_row_2__spl_2_t36 clk_row_2__spl_2_36 clk_row_2__spl_2_37 BEND_PTL_M1
Xclk_row_2__spl_2_t37 clk_row_2__spl_2_37 clk_row_2__spl_2_38 PTL_M1
Xclk_row_2__spl_2_t38 clk_row_2__spl_2_38 clk_row_2__spl_2_39 PTL_M1
Xclk_row_2__spl_2_t39 clk_row_2__spl_2_39 clk_row_2__spl_2_o PTLCAP_M1
Xn6__spl_4_t0 n6__spl_4_i n6__spl_4_1 PTLCAP_M1
Xn6__spl_4_t1 n6__spl_4_1 n6__spl_4_2 BEND_PTL_M1
Xn6__spl_4_t2 n6__spl_4_2 n6__spl_4_3 PTL_M1
Xn6__spl_4_t3 n6__spl_4_3 n6__spl_4_4 PTL_M1
Xn6__spl_4_t4 n6__spl_4_4 n6__spl_4_5 PTL_M1
Xn6__spl_4_t5 n6__spl_4_5 n6__spl_4_6 BEND_PTL_M1
Xn6__spl_4_t6 n6__spl_4_6 n6__spl_4_7 PTL_M1
Xn6__spl_4_t7 n6__spl_4_7 n6__spl_4_8 PTL_M1
Xn6__spl_4_t8 n6__spl_4_8 n6__spl_4_9 PTL_M1
Xn6__spl_4_t9 n6__spl_4_9 n6__spl_4_10 PTL_M1
Xn6__spl_4_t10 n6__spl_4_10 n6__spl_4_11 PTL_M1
Xn6__spl_4_t11 n6__spl_4_11 n6__spl_4_12 PTL_M1
Xn6__spl_4_t12 n6__spl_4_12 n6__spl_4_13 PTL_M1
Xn6__spl_4_t13 n6__spl_4_13 n6__spl_4_14 PTL_M1
Xn6__spl_4_t14 n6__spl_4_14 n6__spl_4_15 PTL_M1
Xn6__spl_4_t15 n6__spl_4_15 n6__spl_4_16 PTL_M1
Xn6__spl_4_t16 n6__spl_4_16 n6__spl_4_17 PTL_M1
Xn6__spl_4_t17 n6__spl_4_17 n6__spl_4_18 PTL_M1
Xn6__spl_4_t18 n6__spl_4_18 n6__spl_4_19 BEND_PTL_M1
Xn6__spl_4_t19 n6__spl_4_19 n6__spl_4_20 PTL_M1
Xn6__spl_4_t20 n6__spl_4_20 n6__spl_4_21 PTL_M1
Xn6__spl_4_t21 n6__spl_4_21 n6__spl_4_22 PTL_M1
Xn6__spl_4_t22 n6__spl_4_22 n6__spl_4_23 PTL_M1
Xn6__spl_4_t23 n6__spl_4_23 n6__spl_4_24 PTL_M1
Xn6__spl_4_t24 n6__spl_4_24 n6__spl_4_25 PTL_M1
Xn6__spl_4_t25 n6__spl_4_25 n6__spl_4_26 PTL_M1
Xn6__spl_4_t26 n6__spl_4_26 n6__spl_4_27 PTL_M1
Xn6__spl_4_t27 n6__spl_4_27 n6__spl_4_28 BEND_PTL_M1
Xn6__spl_4_t28 n6__spl_4_28 n6__spl_4_29 PTL_M1
Xn6__spl_4_t29 n6__spl_4_29 n6__spl_4_30 PTL_M1
Xn6__spl_4_t30 n6__spl_4_30 n6__spl_4_31 PTL_M1
Xn6__spl_4_t31 n6__spl_4_31 n6__spl_4_32 PTL_M1
Xn6__spl_4_t32 n6__spl_4_32 n6__spl_4_33 PTL_M1
Xn6__spl_4_t33 n6__spl_4_33 n6__spl_4_34 PTL_M1
Xn6__spl_4_t34 n6__spl_4_34 n6__spl_4_35 PTL_M1
Xn6__spl_4_t35 n6__spl_4_35 n6__spl_4_36 PTL_M1
Xn6__spl_4_t36 n6__spl_4_36 n6__spl_4_37 PTL_M1
Xn6__spl_4_t37 n6__spl_4_37 n6__spl_4_38 PTL_M1
Xn6__spl_4_t38 n6__spl_4_38 n6__spl_4_39 PTL_M1
Xn6__spl_4_t39 n6__spl_4_39 n6__spl_4_40 PTL_M1
Xn6__spl_4_t40 n6__spl_4_40 n6__spl_4_41 PTL_M1
Xn6__spl_4_t41 n6__spl_4_41 n6__spl_4_42 PTL_M1
Xn6__spl_4_t42 n6__spl_4_42 n6__spl_4_43 PTL_M1
Xn6__spl_4_t43 n6__spl_4_43 n6__spl_4_44 BEND_PTL_M1
Xn6__spl_4_t44 n6__spl_4_44 n6__spl_4_45 PTL_M1
Xn6__spl_4_t45 n6__spl_4_45 n6__spl_4_46 PTL_M1
Xn6__spl_4_t46 n6__spl_4_46 n6__spl_4_47 BEND_PTL_M1
Xn6__spl_4_t47 n6__spl_4_47 n6__spl_4_48 PTL_M1
Xn6__spl_4_t48 n6__spl_4_48 n6__spl_4_49 PTL_M1
Xn6__spl_4_t49 n6__spl_4_49 n6__spl_4_50 PTL_M1
Xn6__spl_4_t50 n6__spl_4_50 n6__spl_4_51 PTL_M1
Xn6__spl_4_t51 n6__spl_4_51 n6__spl_4_52 PTL_M1
Xn6__spl_4_t52 n6__spl_4_52 n6__spl_4_53 PTL_M1
Xn6__spl_4_t53 n6__spl_4_53 n6__spl_4_54 PTL_M1
Xn6__spl_4_t54 n6__spl_4_54 n6__spl_4_55 PTL_M1
Xn6__spl_4_t55 n6__spl_4_55 n6__spl_4_56 PTL_M1
Xn6__spl_4_t56 n6__spl_4_56 n6__spl_4_57 BEND_PTL_M1
Xn6__spl_4_t57 n6__spl_4_57 n6__spl_4_58 PTL_M1
Xn6__spl_4_t58 n6__spl_4_58 n6__spl_4_59 PTL_M1
Xn6__spl_4_t59 n6__spl_4_59 n6__spl_4_60 PTL_M1
Xn6__spl_4_t60 n6__spl_4_60 n6__spl_4_61 PTL_M1
Xn6__spl_4_t61 n6__spl_4_61 n6__spl_4_62 PTL_M1
Xn6__spl_4_t62 n6__spl_4_62 n6__spl_4_63 PTL_M1
Xn6__spl_4_t63 n6__spl_4_63 n6__spl_4_64 PTL_M1
Xn6__spl_4_t64 n6__spl_4_64 n6__spl_4_65 PTL_M1
Xn6__spl_4_t65 n6__spl_4_65 n6__spl_4_66 PTL_M1
Xn6__spl_4_t66 n6__spl_4_66 n6__spl_4_67 PTL_M1
Xn6__spl_4_t67 n6__spl_4_67 n6__spl_4_68 PTL_M1
Xn6__spl_4_t68 n6__spl_4_68 n6__spl_4_69 PTL_M1
Xn6__spl_4_t69 n6__spl_4_69 n6__spl_4_70 PTL_M1
Xn6__spl_4_t70 n6__spl_4_70 n6__spl_4_71 PTL_M1
Xn6__spl_4_t71 n6__spl_4_71 n6__spl_4_72 PTL_M1
Xn6__spl_4_t72 n6__spl_4_72 n6__spl_4_73 PTL_M1
Xn6__spl_4_t73 n6__spl_4_73 n6__spl_4_74 PTL_M1
Xn6__spl_4_t74 n6__spl_4_74 n6__spl_4_75 PTL_M1
Xn6__spl_4_t75 n6__spl_4_75 n6__spl_4_76 BEND_PTL_M1
Xn6__spl_4_t76 n6__spl_4_76 n6__spl_4_77 PTL_M1
Xn6__spl_4_t77 n6__spl_4_77 n6__spl_4_78 PTL_M1
Xn6__spl_4_t78 n6__spl_4_78 n6__spl_4_79 PTL_M1
Xn6__spl_4_t79 n6__spl_4_79 n6__spl_4_80 PTL_M1
Xn6__spl_4_t80 n6__spl_4_80 n6__spl_4_81 PTL_M1
Xn6__spl_4_t81 n6__spl_4_81 n6__spl_4_82 PTL_M1
Xn6__spl_4_t82 n6__spl_4_82 n6__spl_4_83 PTL_M1
Xn6__spl_4_t83 n6__spl_4_83 n6__spl_4_84 PTL_M1
Xn6__spl_4_t84 n6__spl_4_84 n6__spl_4_85 PTL_M1
Xn6__spl_4_t85 n6__spl_4_85 n6__spl_4_86 PTL_M1
Xn6__spl_4_t86 n6__spl_4_86 n6__spl_4_87 PTL_M1
Xn6__spl_4_t87 n6__spl_4_87 n6__spl_4_88 BEND_PTL_M1
Xn6__spl_4_t88 n6__spl_4_88 n6__spl_4_o PTLCAP_M1
Xa0_t0 a0_i a0_1 PTLCAP_M1
Xa0_t1 a0_1 a0_2 PTL_M1
Xa0_t2 a0_2 a0_3 PTL_M1
Xa0_t3 a0_3 a0_4 PTL_M1
Xa0_t4 a0_4 a0_5 PTL_M1
Xa0_t5 a0_5 a0_6 PTL_M1
Xa0_t6 a0_6 a0_7 PTL_M1
Xa0_t7 a0_7 a0_8 PTL_M1
Xa0_t8 a0_8 a0_9 PTL_M1
Xa0_t9 a0_9 a0_10 PTL_M1
Xa0_t10 a0_10 a0_11 PTL_M1
Xa0_t11 a0_11 a0_12 PTL_M1
Xa0_t12 a0_12 a0_13 PTL_M1
Xa0_t13 a0_13 a0_14 BEND_PTL_M1
Xa0_t14 a0_14 a0_15 PTL_M1
Xa0_t15 a0_15 a0_16 PTL_M1
Xa0_t16 a0_16 a0_17 PTL_M1
Xa0_t17 a0_17 a0_18 PTL_M1
Xa0_t18 a0_18 a0_o PTLCAP_M1
Xclk_t0 clk_i clk_1 PTLCAP_M1
Xclk_t1 clk_1 clk_2 PTL_M1
Xclk_t2 clk_2 clk_3 PTL_M1
Xclk_t3 clk_3 clk_4 PTL_M1
Xclk_t4 clk_4 clk_5 PTL_M1
Xclk_t5 clk_5 clk_6 PTL_M1
Xclk_t6 clk_6 clk_7 PTL_M1
Xclk_t7 clk_7 clk_8 PTL_M1
Xclk_t8 clk_8 clk_9 PTL_M1
Xclk_t9 clk_9 clk_10 PTL_M1
Xclk_t10 clk_10 clk_11 PTL_M1
Xclk_t11 clk_11 clk_12 PTL_M1
Xclk_t12 clk_12 clk_13 PTL_M1
Xclk_t13 clk_13 clk_14 PTL_M1
Xclk_t14 clk_14 clk_15 PTL_M1
Xclk_t15 clk_15 clk_16 BEND_PTL_M1
Xclk_t16 clk_16 clk_17 PTL_M1
Xclk_t17 clk_17 clk_18 PTL_M1
Xclk_t18 clk_18 clk_o PTLCAP_M1
Xclk_row_3__spl_1_t0 clk_row_3__spl_1_i clk_row_3__spl_1_1 PTLCAP_M1
Xclk_row_3__spl_1_t1 clk_row_3__spl_1_1 clk_row_3__spl_1_2 PTL_M1
Xclk_row_3__spl_1_t2 clk_row_3__spl_1_2 clk_row_3__spl_1_3 PTL_M1
Xclk_row_3__spl_1_t3 clk_row_3__spl_1_3 clk_row_3__spl_1_4 PTL_M1
Xclk_row_3__spl_1_t4 clk_row_3__spl_1_4 clk_row_3__spl_1_5 PTL_M1
Xclk_row_3__spl_1_t5 clk_row_3__spl_1_5 clk_row_3__spl_1_6 PTL_M1
Xclk_row_3__spl_1_t6 clk_row_3__spl_1_6 clk_row_3__spl_1_7 PTL_M1
Xclk_row_3__spl_1_t7 clk_row_3__spl_1_7 clk_row_3__spl_1_8 BEND_PTL_M1
Xclk_row_3__spl_1_t8 clk_row_3__spl_1_8 clk_row_3__spl_1_9 PTL_M1
Xclk_row_3__spl_1_t9 clk_row_3__spl_1_9 clk_row_3__spl_1_10 PTL_M1
Xclk_row_3__spl_1_t10 clk_row_3__spl_1_10 clk_row_3__spl_1_11 PTL_M1
Xclk_row_3__spl_1_t11 clk_row_3__spl_1_11 clk_row_3__spl_1_12 PTL_M1
Xclk_row_3__spl_1_t12 clk_row_3__spl_1_12 clk_row_3__spl_1_13 PTL_M1
Xclk_row_3__spl_1_t13 clk_row_3__spl_1_13 clk_row_3__spl_1_14 PTL_M1
Xclk_row_3__spl_1_t14 clk_row_3__spl_1_14 clk_row_3__spl_1_15 PTL_M1
Xclk_row_3__spl_1_t15 clk_row_3__spl_1_15 clk_row_3__spl_1_16 PTL_M1
Xclk_row_3__spl_1_t16 clk_row_3__spl_1_16 clk_row_3__spl_1_17 BEND_PTL_M1
Xclk_row_3__spl_1_t17 clk_row_3__spl_1_17 clk_row_3__spl_1_18 PTL_M1
Xclk_row_3__spl_1_t18 clk_row_3__spl_1_18 clk_row_3__spl_1_19 PTL_M1
Xclk_row_3__spl_1_t19 clk_row_3__spl_1_19 clk_row_3__spl_1_20 PTL_M1
Xclk_row_3__spl_1_t20 clk_row_3__spl_1_20 clk_row_3__spl_1_21 PTL_M1
Xclk_row_3__spl_1_t21 clk_row_3__spl_1_21 clk_row_3__spl_1_22 PTL_M1
Xclk_row_3__spl_1_t22 clk_row_3__spl_1_22 clk_row_3__spl_1_23 BEND_PTL_M1
Xclk_row_3__spl_1_t23 clk_row_3__spl_1_23 clk_row_3__spl_1_24 PTL_M1
Xclk_row_3__spl_1_t24 clk_row_3__spl_1_24 clk_row_3__spl_1_25 PTL_M1
Xclk_row_3__spl_1_t25 clk_row_3__spl_1_25 clk_row_3__spl_1_26 PTL_M1
Xclk_row_3__spl_1_t26 clk_row_3__spl_1_26 clk_row_3__spl_1_o PTLCAP_M1
Xn2_t0 n2_i n2_1 PTLCAP_M1
Xn2_t1 n2_1 n2_2 PTL_M1
Xn2_t2 n2_2 n2_3 PTL_M1
Xn2_t3 n2_3 n2_4 PTL_M1
Xn2_t4 n2_4 n2_5 PTL_M1
Xn2_t5 n2_5 n2_6 BEND_PTL_M1
Xn2_t6 n2_6 n2_7 PTL_M1
Xn2_t7 n2_7 n2_8 PTL_M1
Xn2_t8 n2_8 n2_9 PTL_M1
Xn2_t9 n2_9 n2_10 PTL_M1
Xn2_t10 n2_10 n2_11 BEND_PTL_M1
Xn2_t11 n2_11 n2_12 PTL_M1
Xn2_t12 n2_12 n2_13 PTL_M1
Xn2_t13 n2_13 n2_14 PTL_M1
Xn2_t14 n2_14 n2_15 PTL_M1
Xn2_t15 n2_15 n2_16 PTL_M1
Xn2_t16 n2_16 n2_17 PTL_M1
Xn2_t17 n2_17 n2_18 PTL_M1
Xn2_t18 n2_18 n2_19 PTL_M1
Xn2_t19 n2_19 n2_20 BEND_PTL_M1
Xn2_t20 n2_20 n2_o PTLCAP_M1
Xa1_t0 a1_i a1_1 PTLCAP_M1
Xa1_t1 a1_1 a1_2 PTL_M1
Xa1_t2 a1_2 a1_3 PTL_M1
Xa1_t3 a1_3 a1_4 PTL_M1
Xa1_t4 a1_4 a1_5 PTL_M1
Xa1_t5 a1_5 a1_6 PTL_M1
Xa1_t6 a1_6 a1_7 BEND_PTL_M1
Xa1_t7 a1_7 a1_8 PTL_M1
Xa1_t8 a1_8 a1_9 PTL_M1
Xa1_t9 a1_9 a1_10 PTL_M1
Xa1_t10 a1_10 a1_11 PTL_M1
Xa1_t11 a1_11 a1_12 PTL_M1
Xa1_t12 a1_12 a1_13 PTL_M1
Xa1_t13 a1_13 a1_14 PTL_M1
Xa1_t14 a1_14 a1_15 PTL_M1
Xa1_t15 a1_15 a1_16 PTL_M1
Xa1_t16 a1_16 a1_17 PTL_M1
Xa1_t17 a1_17 a1_18 PTL_M1
Xa1_t18 a1_18 a1_19 PTL_M1
Xa1_t19 a1_19 a1_o PTLCAP_M1
Xn2__spl_13_t0 n2__spl_13_i n2__spl_13_1 PTLCAP_M1
Xn2__spl_13_t1 n2__spl_13_1 n2__spl_13_2 BEND_PTL_M1
Xn2__spl_13_t2 n2__spl_13_2 n2__spl_13_3 PTL_M1
Xn2__spl_13_t3 n2__spl_13_3 n2__spl_13_4 PTL_M1
Xn2__spl_13_t4 n2__spl_13_4 n2__spl_13_5 PTL_M1
Xn2__spl_13_t5 n2__spl_13_5 n2__spl_13_6 PTL_M1
Xn2__spl_13_t6 n2__spl_13_6 n2__spl_13_7 PTL_M1
Xn2__spl_13_t7 n2__spl_13_7 n2__spl_13_8 PTL_M1
Xn2__spl_13_t8 n2__spl_13_8 n2__spl_13_9 PTL_M1
Xn2__spl_13_t9 n2__spl_13_9 n2__spl_13_10 PTL_M1
Xn2__spl_13_t10 n2__spl_13_10 n2__spl_13_11 PTL_M1
Xn2__spl_13_t11 n2__spl_13_11 n2__spl_13_12 PTL_M1
Xn2__spl_13_t12 n2__spl_13_12 n2__spl_13_13 PTL_M1
Xn2__spl_13_t13 n2__spl_13_13 n2__spl_13_14 PTL_M1
Xn2__spl_13_t14 n2__spl_13_14 n2__spl_13_15 PTL_M1
Xn2__spl_13_t15 n2__spl_13_15 n2__spl_13_16 PTL_M1
Xn2__spl_13_t16 n2__spl_13_16 n2__spl_13_17 PTL_M1
Xn2__spl_13_t17 n2__spl_13_17 n2__spl_13_18 BEND_PTL_M1
Xn2__spl_13_t18 n2__spl_13_18 n2__spl_13_19 PTL_M1
Xn2__spl_13_t19 n2__spl_13_19 n2__spl_13_20 PTL_M1
Xn2__spl_13_t20 n2__spl_13_20 n2__spl_13_21 PTL_M1
Xn2__spl_13_t21 n2__spl_13_21 n2__spl_13_22 PTL_M1
Xn2__spl_13_t22 n2__spl_13_22 n2__spl_13_23 BEND_PTL_M1
Xn2__spl_13_t23 n2__spl_13_23 n2__spl_13_o PTLCAP_M1
Xb0_t0 b0_i b0_1 PTLCAP_M1
Xb0_t1 b0_1 b0_2 PTL_M1
Xb0_t2 b0_2 b0_3 PTL_M1
Xb0_t3 b0_3 b0_4 PTL_M1
Xb0_t4 b0_4 b0_5 PTL_M1
Xb0_t5 b0_5 b0_6 PTL_M1
Xb0_t6 b0_6 b0_7 PTL_M1
Xb0_t7 b0_7 b0_8 PTL_M1
Xb0_t8 b0_8 b0_9 PTL_M1
Xb0_t9 b0_9 b0_10 PTL_M1
Xb0_t10 b0_10 b0_11 PTL_M1
Xb0_t11 b0_11 b0_12 PTL_M1
Xb0_t12 b0_12 b0_13 PTL_M1
Xb0_t13 b0_13 b0_14 PTL_M1
Xb0_t14 b0_14 b0_15 BEND_PTL_M1
Xb0_t15 b0_15 b0_16 PTL_M1
Xb0_t16 b0_16 b0_17 PTL_M1
Xb0_t17 b0_17 b0_18 PTL_M1
Xb0_t18 b0_18 b0_19 PTL_M1
Xb0_t19 b0_19 b0_20 PTL_M1
Xb0_t20 b0_20 b0_21 PTL_M1
Xb0_t21 b0_21 b0_22 PTL_M1
Xb0_t22 b0_22 b0_23 BEND_PTL_M1
Xb0_t23 b0_23 b0_o PTLCAP_M1
Xn2__spl_14_t0 n2__spl_14_i n2__spl_14_1 PTLCAP_M1
Xn2__spl_14_t1 n2__spl_14_1 n2__spl_14_2 PTL_M1
Xn2__spl_14_t2 n2__spl_14_2 n2__spl_14_3 PTL_M1
Xn2__spl_14_t3 n2__spl_14_3 n2__spl_14_4 PTL_M1
Xn2__spl_14_t4 n2__spl_14_4 n2__spl_14_5 PTL_M1
Xn2__spl_14_t5 n2__spl_14_5 n2__spl_14_6 BEND_PTL_M1
Xn2__spl_14_t6 n2__spl_14_6 n2__spl_14_7 PTL_M1
Xn2__spl_14_t7 n2__spl_14_7 n2__spl_14_8 PTL_M1
Xn2__spl_14_t8 n2__spl_14_8 n2__spl_14_9 PTL_M1
Xn2__spl_14_t9 n2__spl_14_9 n2__spl_14_10 PTL_M1
Xn2__spl_14_t10 n2__spl_14_10 n2__spl_14_11 PTL_M1
Xn2__spl_14_t11 n2__spl_14_11 n2__spl_14_12 PTL_M1
Xn2__spl_14_t12 n2__spl_14_12 n2__spl_14_13 PTL_M1
Xn2__spl_14_t13 n2__spl_14_13 n2__spl_14_14 PTL_M1
Xn2__spl_14_t14 n2__spl_14_14 n2__spl_14_15 PTL_M1
Xn2__spl_14_t15 n2__spl_14_15 n2__spl_14_16 PTL_M1
Xn2__spl_14_t16 n2__spl_14_16 n2__spl_14_17 PTL_M1
Xn2__spl_14_t17 n2__spl_14_17 n2__spl_14_18 PTL_M1
Xn2__spl_14_t18 n2__spl_14_18 n2__spl_14_19 PTL_M1
Xn2__spl_14_t19 n2__spl_14_19 n2__spl_14_20 PTL_M1
Xn2__spl_14_t20 n2__spl_14_20 n2__spl_14_21 PTL_M1
Xn2__spl_14_t21 n2__spl_14_21 n2__spl_14_o PTLCAP_M1
Xa0__spl_11_t0 a0__spl_11_i a0__spl_11_1 PTLCAP_M1
Xa0__spl_11_t1 a0__spl_11_1 a0__spl_11_2 BEND_PTL_M1
Xa0__spl_11_t2 a0__spl_11_2 a0__spl_11_3 PTL_M1
Xa0__spl_11_t3 a0__spl_11_3 a0__spl_11_4 BEND_PTL_M1
Xa0__spl_11_t4 a0__spl_11_4 a0__spl_11_5 PTL_M1
Xa0__spl_11_t5 a0__spl_11_5 a0__spl_11_6 PTL_M1
Xa0__spl_11_t6 a0__spl_11_6 a0__spl_11_7 PTL_M1
Xa0__spl_11_t7 a0__spl_11_7 a0__spl_11_8 PTL_M1
Xa0__spl_11_t8 a0__spl_11_8 a0__spl_11_9 PTL_M1
Xa0__spl_11_t9 a0__spl_11_9 a0__spl_11_10 PTL_M1
Xa0__spl_11_t10 a0__spl_11_10 a0__spl_11_11 PTL_M1
Xa0__spl_11_t11 a0__spl_11_11 a0__spl_11_12 PTL_M1
Xa0__spl_11_t12 a0__spl_11_12 a0__spl_11_13 PTL_M1
Xa0__spl_11_t13 a0__spl_11_13 a0__spl_11_14 PTL_M1
Xa0__spl_11_t14 a0__spl_11_14 a0__spl_11_15 BEND_PTL_M1
Xa0__spl_11_t15 a0__spl_11_15 a0__spl_11_16 PTL_M1
Xa0__spl_11_t16 a0__spl_11_16 a0__spl_11_17 PTL_M1
Xa0__spl_11_t17 a0__spl_11_17 a0__spl_11_18 PTL_M1
Xa0__spl_11_t18 a0__spl_11_18 a0__spl_11_19 PTL_M1
Xa0__spl_11_t19 a0__spl_11_19 a0__spl_11_20 PTL_M1
Xa0__spl_11_t20 a0__spl_11_20 a0__spl_11_21 PTL_M1
Xa0__spl_11_t21 a0__spl_11_21 a0__spl_11_22 PTL_M1
Xa0__spl_11_t22 a0__spl_11_22 a0__spl_11_23 PTL_M1
Xa0__spl_11_t23 a0__spl_11_23 a0__spl_11_24 PTL_M1
Xa0__spl_11_t24 a0__spl_11_24 a0__spl_11_25 PTL_M1
Xa0__spl_11_t25 a0__spl_11_25 a0__spl_11_26 PTL_M1
Xa0__spl_11_t26 a0__spl_11_26 a0__spl_11_27 PTL_M1
Xa0__spl_11_t27 a0__spl_11_27 a0__spl_11_28 PTL_M1
Xa0__spl_11_t28 a0__spl_11_28 a0__spl_11_29 PTL_M1
Xa0__spl_11_t29 a0__spl_11_29 a0__spl_11_30 BEND_PTL_M1
Xa0__spl_11_t30 a0__spl_11_30 a0__spl_11_o PTLCAP_M1
Xb0__spl_6_t0 b0__spl_6_i b0__spl_6_1 PTLCAP_M1
Xb0__spl_6_t1 b0__spl_6_1 b0__spl_6_2 PTL_M1
Xb0__spl_6_t2 b0__spl_6_2 b0__spl_6_3 BEND_PTL_M1
Xb0__spl_6_t3 b0__spl_6_3 b0__spl_6_4 PTL_M1
Xb0__spl_6_t4 b0__spl_6_4 b0__spl_6_5 PTL_M1
Xb0__spl_6_t5 b0__spl_6_5 b0__spl_6_6 PTL_M1
Xb0__spl_6_t6 b0__spl_6_6 b0__spl_6_7 PTL_M1
Xb0__spl_6_t7 b0__spl_6_7 b0__spl_6_8 PTL_M1
Xb0__spl_6_t8 b0__spl_6_8 b0__spl_6_9 PTL_M1
Xb0__spl_6_t9 b0__spl_6_9 b0__spl_6_10 PTL_M1
Xb0__spl_6_t10 b0__spl_6_10 b0__spl_6_11 PTL_M1
Xb0__spl_6_t11 b0__spl_6_11 b0__spl_6_12 PTL_M1
Xb0__spl_6_t12 b0__spl_6_12 b0__spl_6_13 PTL_M1
Xb0__spl_6_t13 b0__spl_6_13 b0__spl_6_14 PTL_M1
Xb0__spl_6_t14 b0__spl_6_14 b0__spl_6_15 PTL_M1
Xb0__spl_6_t15 b0__spl_6_15 b0__spl_6_16 PTL_M1
Xb0__spl_6_t16 b0__spl_6_16 b0__spl_6_17 PTL_M1
Xb0__spl_6_t17 b0__spl_6_17 b0__spl_6_18 PTL_M1
Xb0__spl_6_t18 b0__spl_6_18 b0__spl_6_19 PTL_M1
Xb0__spl_6_t19 b0__spl_6_19 b0__spl_6_20 PTL_M1
Xb0__spl_6_t20 b0__spl_6_20 b0__spl_6_21 PTL_M1
Xb0__spl_6_t21 b0__spl_6_21 b0__spl_6_22 PTL_M1
Xb0__spl_6_t22 b0__spl_6_22 b0__spl_6_23 BEND_PTL_M1
Xb0__spl_6_t23 b0__spl_6_23 b0__spl_6_24 PTL_M1
Xb0__spl_6_t24 b0__spl_6_24 b0__spl_6_25 PTL_M1
Xb0__spl_6_t25 b0__spl_6_25 b0__spl_6_26 BEND_PTL_M1
Xb0__spl_6_t26 b0__spl_6_26 b0__spl_6_27 BEND_PTL_M1
Xb0__spl_6_t27 b0__spl_6_27 b0__spl_6_28 PTL_M1
Xb0__spl_6_t28 b0__spl_6_28 b0__spl_6_29 PTL_M1
Xb0__spl_6_t29 b0__spl_6_29 b0__spl_6_30 PTL_M1
Xb0__spl_6_t30 b0__spl_6_30 b0__spl_6_o PTLCAP_M1
Xp1__out_entry_4_t0 p1__out_entry_4_i p1__out_entry_4_1 PTLCAP_M1
Xp1__out_entry_4_t1 p1__out_entry_4_1 p1__out_entry_4_2 BEND_PTL_M1
Xp1__out_entry_4_t2 p1__out_entry_4_2 p1__out_entry_4_3 PTL_M1
Xp1__out_entry_4_t3 p1__out_entry_4_3 p1__out_entry_4_4 PTL_M1
Xp1__out_entry_4_t4 p1__out_entry_4_4 p1__out_entry_4_5 PTL_M1
Xp1__out_entry_4_t5 p1__out_entry_4_5 p1__out_entry_4_6 PTL_M1
Xp1__out_entry_4_t6 p1__out_entry_4_6 p1__out_entry_4_7 BEND_PTL_M1
Xp1__out_entry_4_t7 p1__out_entry_4_7 p1__out_entry_4_8 PTL_M1
Xp1__out_entry_4_t8 p1__out_entry_4_8 p1__out_entry_4_9 PTL_M1
Xp1__out_entry_4_t9 p1__out_entry_4_9 p1__out_entry_4_10 PTL_M1
Xp1__out_entry_4_t10 p1__out_entry_4_10 p1__out_entry_4_11 PTL_M1
Xp1__out_entry_4_t11 p1__out_entry_4_11 p1__out_entry_4_12 PTL_M1
Xp1__out_entry_4_t12 p1__out_entry_4_12 p1__out_entry_4_13 PTL_M1
Xp1__out_entry_4_t13 p1__out_entry_4_13 p1__out_entry_4_14 BEND_PTL_M1
Xp1__out_entry_4_t14 p1__out_entry_4_14 p1__out_entry_4_15 PTL_M1
Xp1__out_entry_4_t15 p1__out_entry_4_15 p1__out_entry_4_16 PTL_M1
Xp1__out_entry_4_t16 p1__out_entry_4_16 p1__out_entry_4_17 PTL_M1
Xp1__out_entry_4_t17 p1__out_entry_4_17 p1__out_entry_4_18 PTL_M1
Xp1__out_entry_4_t18 p1__out_entry_4_18 p1__out_entry_4_19 PTL_M1
Xp1__out_entry_4_t19 p1__out_entry_4_19 p1__out_entry_4_20 BEND_PTL_M1
Xp1__out_entry_4_t20 p1__out_entry_4_20 p1__out_entry_4_21 PTL_M1
Xp1__out_entry_4_t21 p1__out_entry_4_21 p1__out_entry_4_22 BEND_PTL_M1
Xp1__out_entry_4_t22 p1__out_entry_4_22 p1__out_entry_4_23 PTL_M1
Xp1__out_entry_4_t23 p1__out_entry_4_23 p1__out_entry_4_24 PTL_M1
Xp1__out_entry_4_t24 p1__out_entry_4_24 p1__out_entry_4_25 PTL_M1
Xp1__out_entry_4_t25 p1__out_entry_4_25 p1__out_entry_4_26 PTL_M1
Xp1__out_entry_4_t26 p1__out_entry_4_26 p1__out_entry_4_27 PTL_M1
Xp1__out_entry_4_t27 p1__out_entry_4_27 p1__out_entry_4_28 PTL_M1
Xp1__out_entry_4_t28 p1__out_entry_4_28 p1__out_entry_4_29 PTL_M1
Xp1__out_entry_4_t29 p1__out_entry_4_29 p1__out_entry_4_30 PTL_M1
Xp1__out_entry_4_t30 p1__out_entry_4_30 p1__out_entry_4_31 PTL_M1
Xp1__out_entry_4_t31 p1__out_entry_4_31 p1__out_entry_4_32 PTL_M1
Xp1__out_entry_4_t32 p1__out_entry_4_32 p1__out_entry_4_33 PTL_M1
Xp1__out_entry_4_t33 p1__out_entry_4_33 p1__out_entry_4_34 PTL_M1
Xp1__out_entry_4_t34 p1__out_entry_4_34 p1__out_entry_4_35 PTL_M1
Xp1__out_entry_4_t35 p1__out_entry_4_35 p1__out_entry_4_36 PTL_M1
Xp1__out_entry_4_t36 p1__out_entry_4_36 p1__out_entry_4_37 PTL_M1
Xp1__out_entry_4_t37 p1__out_entry_4_37 p1__out_entry_4_38 PTL_M1
Xp1__out_entry_4_t38 p1__out_entry_4_38 p1__out_entry_4_39 PTL_M1
Xp1__out_entry_4_t39 p1__out_entry_4_39 p1__out_entry_4_40 PTL_M1
Xp1__out_entry_4_t40 p1__out_entry_4_40 p1__out_entry_4_41 PTL_M1
Xp1__out_entry_4_t41 p1__out_entry_4_41 p1__out_entry_4_42 PTL_M1
Xp1__out_entry_4_t42 p1__out_entry_4_42 p1__out_entry_4_43 BEND_PTL_M1
Xp1__out_entry_4_t43 p1__out_entry_4_43 p1__out_entry_4_44 PTL_M1
Xp1__out_entry_4_t44 p1__out_entry_4_44 p1__out_entry_4_45 PTL_M1
Xp1__out_entry_4_t45 p1__out_entry_4_45 p1__out_entry_4_46 PTL_M1
Xp1__out_entry_4_t46 p1__out_entry_4_46 p1__out_entry_4_o PTLCAP_M1
Xp2_t0 p2_i p2_1 PTLCAP_M1
Xp2_t1 p2_1 p2_2 PTL_M1
Xp2_t2 p2_2 p2_3 BEND_PTL_M1
Xp2_t3 p2_3 p2_4 PTL_M1
Xp2_t4 p2_4 p2_5 PTL_M1
Xp2_t5 p2_5 p2_6 PTL_M1
Xp2_t6 p2_6 p2_7 BEND_PTL_M1
Xp2_t7 p2_7 p2_8 PTL_M1
Xp2_t8 p2_8 p2_9 PTL_M1
Xp2_t9 p2_9 p2_10 PTL_M1
Xp2_t10 p2_10 p2_11 BEND_PTL_M1
Xp2_t11 p2_11 p2_12 PTL_M1
Xp2_t12 p2_12 p2_13 PTL_M1
Xp2_t13 p2_13 p2_14 PTL_M1
Xp2_t14 p2_14 p2_15 PTL_M1
Xp2_t15 p2_15 p2_16 PTL_M1
Xp2_t16 p2_16 p2_17 PTL_M1
Xp2_t17 p2_17 p2_18 PTL_M1
Xp2_t18 p2_18 p2_19 PTL_M1
Xp2_t19 p2_19 p2_20 PTL_M1
Xp2_t20 p2_20 p2_21 BEND_PTL_M1
Xp2_t21 p2_21 p2_22 PTL_M1
Xp2_t22 p2_22 p2_23 PTL_M1
Xp2_t23 p2_23 p2_24 PTL_M1
Xp2_t24 p2_24 p2_25 PTL_M1
Xp2_t25 p2_25 p2_26 PTL_M1
Xp2_t26 p2_26 p2_27 PTL_M1
Xp2_t27 p2_27 p2_28 PTL_M1
Xp2_t28 p2_28 p2_29 PTL_M1
Xp2_t29 p2_29 p2_30 PTL_M1
Xp2_t30 p2_30 p2_31 PTL_M1
Xp2_t31 p2_31 p2_32 PTL_M1
Xp2_t32 p2_32 p2_33 PTL_M1
Xp2_t33 p2_33 p2_34 PTL_M1
Xp2_t34 p2_34 p2_35 PTL_M1
Xp2_t35 p2_35 p2_36 PTL_M1
Xp2_t36 p2_36 p2_37 PTL_M1
Xp2_t37 p2_37 p2_38 PTL_M1
Xp2_t38 p2_38 p2_39 PTL_M1
Xp2_t39 p2_39 p2_40 PTL_M1
Xp2_t40 p2_40 p2_41 PTL_M1
Xp2_t41 p2_41 p2_42 PTL_M1
Xp2_t42 p2_42 p2_43 PTL_M1
Xp2_t43 p2_43 p2_44 BEND_PTL_M1
Xp2_t44 p2_44 p2_45 PTL_M1
Xp2_t45 p2_45 p2_46 PTL_M1
Xp2_t46 p2_46 p2_47 PTL_M1
Xp2_t47 p2_47 p2_48 PTL_M1
Xp2_t48 p2_48 p2_49 PTL_M1
Xp2_t49 p2_49 p2_50 PTL_M1
Xp2_t50 p2_50 p2_51 PTL_M1
Xp2_t51 p2_51 p2_52 PTL_M1
Xp2_t52 p2_52 p2_53 BEND_PTL_M1
Xp2_t53 p2_53 p2_o PTLCAP_M1
Xb1__spl_2_t0 b1__spl_2_i b1__spl_2_1 PTLCAP_M1
Xb1__spl_2_t1 b1__spl_2_1 b1__spl_2_2 PTL_M1
Xb1__spl_2_t2 b1__spl_2_2 b1__spl_2_3 PTL_M1
Xb1__spl_2_t3 b1__spl_2_3 b1__spl_2_4 PTL_M1
Xb1__spl_2_t4 b1__spl_2_4 b1__spl_2_5 PTL_M1
Xb1__spl_2_t5 b1__spl_2_5 b1__spl_2_6 BEND_PTL_M1
Xb1__spl_2_t6 b1__spl_2_6 b1__spl_2_7 PTL_M1
Xb1__spl_2_t7 b1__spl_2_7 b1__spl_2_8 PTL_M1
Xb1__spl_2_t8 b1__spl_2_8 b1__spl_2_9 PTL_M1
Xb1__spl_2_t9 b1__spl_2_9 b1__spl_2_10 PTL_M1
Xb1__spl_2_t10 b1__spl_2_10 b1__spl_2_11 PTL_M1
Xb1__spl_2_t11 b1__spl_2_11 b1__spl_2_12 PTL_M1
Xb1__spl_2_t12 b1__spl_2_12 b1__spl_2_13 PTL_M1
Xb1__spl_2_t13 b1__spl_2_13 b1__spl_2_14 PTL_M1
Xb1__spl_2_t14 b1__spl_2_14 b1__spl_2_15 PTL_M1
Xb1__spl_2_t15 b1__spl_2_15 b1__spl_2_16 PTL_M1
Xb1__spl_2_t16 b1__spl_2_16 b1__spl_2_17 PTL_M1
Xb1__spl_2_t17 b1__spl_2_17 b1__spl_2_18 PTL_M1
Xb1__spl_2_t18 b1__spl_2_18 b1__spl_2_19 PTL_M1
Xb1__spl_2_t19 b1__spl_2_19 b1__spl_2_20 PTL_M1
Xb1__spl_2_t20 b1__spl_2_20 b1__spl_2_21 PTL_M1
Xb1__spl_2_t21 b1__spl_2_21 b1__spl_2_22 PTL_M1
Xb1__spl_2_t22 b1__spl_2_22 b1__spl_2_23 PTL_M1
Xb1__spl_2_t23 b1__spl_2_23 b1__spl_2_24 PTL_M1
Xb1__spl_2_t24 b1__spl_2_24 b1__spl_2_25 BEND_PTL_M1
Xb1__spl_2_t25 b1__spl_2_25 b1__spl_2_o PTLCAP_M1
Xp3_t0 p3_i p3_1 PTLCAP_M1
Xp3_t1 p3_1 p3_2 PTL_M1
Xp3_t2 p3_2 p3_3 PTL_M1
Xp3_t3 p3_3 p3_4 PTL_M1
Xp3_t4 p3_4 p3_5 PTL_M1
Xp3_t5 p3_5 p3_6 PTL_M1
Xp3_t6 p3_6 p3_7 PTL_M1
Xp3_t7 p3_7 p3_8 PTL_M1
Xp3_t8 p3_8 p3_9 PTL_M1
Xp3_t9 p3_9 p3_10 PTL_M1
Xp3_t10 p3_10 p3_11 PTL_M1
Xp3_t11 p3_11 p3_12 PTL_M1
Xp3_t12 p3_12 p3_13 PTL_M1
Xp3_t13 p3_13 p3_14 PTL_M1
Xp3_t14 p3_14 p3_15 PTL_M1
Xp3_t15 p3_15 p3_16 PTL_M1
Xp3_t16 p3_16 p3_17 PTL_M1
Xp3_t17 p3_17 p3_18 PTL_M1
Xp3_t18 p3_18 p3_19 PTL_M1
Xp3_t19 p3_19 p3_20 PTL_M1
Xp3_t20 p3_20 p3_21 PTL_M1
Xp3_t21 p3_21 p3_22 PTL_M1
Xp3_t22 p3_22 p3_23 BEND_PTL_M1
Xp3_t23 p3_23 p3_24 PTL_M1
Xp3_t24 p3_24 p3_25 PTL_M1
Xp3_t25 p3_25 p3_26 PTL_M1
Xp3_t26 p3_26 p3_o PTLCAP_M1
Xclk_row_3_t0 clk_row_3_i clk_row_3_1 PTLCAP_M1
Xclk_row_3_t1 clk_row_3_1 clk_row_3_2 PTL_M1
Xclk_row_3_t2 clk_row_3_2 clk_row_3_3 PTL_M1
Xclk_row_3_t3 clk_row_3_3 clk_row_3_4 PTL_M1
Xclk_row_3_t4 clk_row_3_4 clk_row_3_5 PTL_M1
Xclk_row_3_t5 clk_row_3_5 clk_row_3_6 PTL_M1
Xclk_row_3_t6 clk_row_3_6 clk_row_3_7 PTL_M1
Xclk_row_3_t7 clk_row_3_7 clk_row_3_8 PTL_M1
Xclk_row_3_t8 clk_row_3_8 clk_row_3_9 PTL_M1
Xclk_row_3_t9 clk_row_3_9 clk_row_3_10 PTL_M1
Xclk_row_3_t10 clk_row_3_10 clk_row_3_11 PTL_M1
Xclk_row_3_t11 clk_row_3_11 clk_row_3_12 PTL_M1
Xclk_row_3_t12 clk_row_3_12 clk_row_3_13 PTL_M1
Xclk_row_3_t13 clk_row_3_13 clk_row_3_14 BEND_PTL_M1
Xclk_row_3_t14 clk_row_3_14 clk_row_3_15 PTL_M1
Xclk_row_3_t15 clk_row_3_15 clk_row_3_16 PTL_M1
Xclk_row_3_t16 clk_row_3_16 clk_row_3_17 PTL_M1
Xclk_row_3_t17 clk_row_3_17 clk_row_3_18 PTL_M1
Xclk_row_3_t18 clk_row_3_18 clk_row_3_19 PTL_M1
Xclk_row_3_t19 clk_row_3_19 clk_row_3_20 PTL_M1
Xclk_row_3_t20 clk_row_3_20 clk_row_3_21 PTL_M1
Xclk_row_3_t21 clk_row_3_21 clk_row_3_22 PTL_M1
Xclk_row_3_t22 clk_row_3_22 clk_row_3_23 PTL_M1
Xclk_row_3_t23 clk_row_3_23 clk_row_3_24 PTL_M1
Xclk_row_3_t24 clk_row_3_24 clk_row_3_25 PTL_M1
Xclk_row_3_t25 clk_row_3_25 clk_row_3_26 PTL_M1
Xclk_row_3_t26 clk_row_3_26 clk_row_3_27 PTL_M1
Xclk_row_3_t27 clk_row_3_27 clk_row_3_28 PTL_M1
Xclk_row_3_t28 clk_row_3_28 clk_row_3_29 PTL_M1
Xclk_row_3_t29 clk_row_3_29 clk_row_3_30 PTL_M1
Xclk_row_3_t30 clk_row_3_30 clk_row_3_31 PTL_M1
Xclk_row_3_t31 clk_row_3_31 clk_row_3_32 PTL_M1
Xclk_row_3_t32 clk_row_3_32 clk_row_3_33 PTL_M1
Xclk_row_3_t33 clk_row_3_33 clk_row_3_34 PTL_M1
Xclk_row_3_t34 clk_row_3_34 clk_row_3_35 PTL_M1
Xclk_row_3_t35 clk_row_3_35 clk_row_3_36 PTL_M1
Xclk_row_3_t36 clk_row_3_36 clk_row_3_37 PTL_M1
Xclk_row_3_t37 clk_row_3_37 clk_row_3_38 PTL_M1
Xclk_row_3_t38 clk_row_3_38 clk_row_3_39 PTL_M1
Xclk_row_3_t39 clk_row_3_39 clk_row_3_40 BEND_PTL_M1
Xclk_row_3_t40 clk_row_3_40 clk_row_3_41 PTL_M1
Xclk_row_3_t41 clk_row_3_41 clk_row_3_42 PTL_M1
Xclk_row_3_t42 clk_row_3_42 clk_row_3_43 PTL_M1
Xclk_row_3_t43 clk_row_3_43 clk_row_3_44 PTL_M1
Xclk_row_3_t44 clk_row_3_44 clk_row_3_45 PTL_M1
Xclk_row_3_t45 clk_row_3_45 clk_row_3_46 PTL_M1
Xclk_row_3_t46 clk_row_3_46 clk_row_3_o PTLCAP_M1
Xclk_row_1_t0 clk_row_1_i clk_row_1_1 PTLCAP_M1
Xclk_row_1_t1 clk_row_1_1 clk_row_1_2 PTL_M1
Xclk_row_1_t2 clk_row_1_2 clk_row_1_3 PTL_M1
Xclk_row_1_t3 clk_row_1_3 clk_row_1_4 PTL_M1
Xclk_row_1_t4 clk_row_1_4 clk_row_1_5 PTL_M1
Xclk_row_1_t5 clk_row_1_5 clk_row_1_6 PTL_M1
Xclk_row_1_t6 clk_row_1_6 clk_row_1_7 PTL_M1
Xclk_row_1_t7 clk_row_1_7 clk_row_1_8 PTL_M1
Xclk_row_1_t8 clk_row_1_8 clk_row_1_9 PTL_M1
Xclk_row_1_t9 clk_row_1_9 clk_row_1_10 PTL_M1
Xclk_row_1_t10 clk_row_1_10 clk_row_1_11 PTL_M1
Xclk_row_1_t11 clk_row_1_11 clk_row_1_12 PTL_M1
Xclk_row_1_t12 clk_row_1_12 clk_row_1_13 PTL_M1
Xclk_row_1_t13 clk_row_1_13 clk_row_1_14 PTL_M1
Xclk_row_1_t14 clk_row_1_14 clk_row_1_15 PTL_M1
Xclk_row_1_t15 clk_row_1_15 clk_row_1_16 PTL_M1
Xclk_row_1_t16 clk_row_1_16 clk_row_1_17 PTL_M1
Xclk_row_1_t17 clk_row_1_17 clk_row_1_18 PTL_M1
Xclk_row_1_t18 clk_row_1_18 clk_row_1_19 BEND_PTL_M1
Xclk_row_1_t19 clk_row_1_19 clk_row_1_20 PTL_M1
Xclk_row_1_t20 clk_row_1_20 clk_row_1_21 PTL_M1
Xclk_row_1_t21 clk_row_1_21 clk_row_1_22 PTL_M1
Xclk_row_1_t22 clk_row_1_22 clk_row_1_23 PTL_M1
Xclk_row_1_t23 clk_row_1_23 clk_row_1_24 PTL_M1
Xclk_row_1_t24 clk_row_1_24 clk_row_1_25 PTL_M1
Xclk_row_1_t25 clk_row_1_25 clk_row_1_26 PTL_M1
Xclk_row_1_t26 clk_row_1_26 clk_row_1_27 PTL_M1
Xclk_row_1_t27 clk_row_1_27 clk_row_1_28 PTL_M1
Xclk_row_1_t28 clk_row_1_28 clk_row_1_29 PTL_M1
Xclk_row_1_t29 clk_row_1_29 clk_row_1_30 PTL_M1
Xclk_row_1_t30 clk_row_1_30 clk_row_1_31 PTL_M1
Xclk_row_1_t31 clk_row_1_31 clk_row_1_32 PTL_M1
Xclk_row_1_t32 clk_row_1_32 clk_row_1_33 PTL_M1
Xclk_row_1_t33 clk_row_1_33 clk_row_1_34 BEND_PTL_M1
Xclk_row_1_t34 clk_row_1_34 clk_row_1_35 PTL_M1
Xclk_row_1_t35 clk_row_1_35 clk_row_1_36 PTL_M1
Xclk_row_1_t36 clk_row_1_36 clk_row_1_37 PTL_M1
Xclk_row_1_t37 clk_row_1_37 clk_row_1_38 PTL_M1
Xclk_row_1_t38 clk_row_1_38 clk_row_1_39 PTL_M1
Xclk_row_1_t39 clk_row_1_39 clk_row_1_40 PTL_M1
Xclk_row_1_t40 clk_row_1_40 clk_row_1_41 BEND_PTL_M1
Xclk_row_1_t41 clk_row_1_41 clk_row_1_42 BEND_PTL_M1
Xclk_row_1_t42 clk_row_1_42 clk_row_1_43 PTL_M1
Xclk_row_1_t43 clk_row_1_43 clk_row_1_44 BEND_PTL_M1
Xclk_row_1_t44 clk_row_1_44 clk_row_1_45 PTL_M1
Xclk_row_1_t45 clk_row_1_45 clk_row_1_46 PTL_M1
Xclk_row_1_t46 clk_row_1_46 clk_row_1_47 PTL_M1
Xclk_row_1_t47 clk_row_1_47 clk_row_1_48 PTL_M1
Xclk_row_1_t48 clk_row_1_48 clk_row_1_49 PTL_M1
Xclk_row_1_t49 clk_row_1_49 clk_row_1_50 BEND_PTL_M1
Xclk_row_1_t50 clk_row_1_50 clk_row_1_o PTLCAP_M1
Xclk_row_1__spl_5_t0 clk_row_1__spl_5_i clk_row_1__spl_5_1 PTLCAP_M3
Xclk_row_1__spl_5_t1 clk_row_1__spl_5_1 clk_row_1__spl_5_2 PTL_M3
Xclk_row_1__spl_5_t2 clk_row_1__spl_5_2 clk_row_1__spl_5_3 PTL_M3
Xclk_row_1__spl_5_t3 clk_row_1__spl_5_3 clk_row_1__spl_5_4 PTL_M3
Xclk_row_1__spl_5_t4 clk_row_1__spl_5_4 clk_row_1__spl_5_5 PTL_M3
Xclk_row_1__spl_5_t5 clk_row_1__spl_5_5 clk_row_1__spl_5_6 PTL_M3
Xclk_row_1__spl_5_t6 clk_row_1__spl_5_6 clk_row_1__spl_5_7 BEND_PTL_M3
Xclk_row_1__spl_5_t7 clk_row_1__spl_5_7 clk_row_1__spl_5_8 PTL_M3
Xclk_row_1__spl_5_t8 clk_row_1__spl_5_8 clk_row_1__spl_5_9 PTL_M3
Xclk_row_1__spl_5_t9 clk_row_1__spl_5_9 clk_row_1__spl_5_10 PTL_M3
Xclk_row_1__spl_5_t10 clk_row_1__spl_5_10 clk_row_1__spl_5_11 PTL_M3
Xclk_row_1__spl_5_t11 clk_row_1__spl_5_11 clk_row_1__spl_5_12 PTL_M3
Xclk_row_1__spl_5_t12 clk_row_1__spl_5_12 clk_row_1__spl_5_13 PTL_M3
Xclk_row_1__spl_5_t13 clk_row_1__spl_5_13 clk_row_1__spl_5_14 PTL_M3
Xclk_row_1__spl_5_t14 clk_row_1__spl_5_14 clk_row_1__spl_5_15 PTL_M3
Xclk_row_1__spl_5_t15 clk_row_1__spl_5_15 clk_row_1__spl_5_o PTLCAP_M3
Xn4_t0 n4_i n4_1 PTLCAP_M3
Xn4_t1 n4_1 n4_2 BEND_PTL_M3
Xn4_t2 n4_2 n4_3 PTL_M3
Xn4_t3 n4_3 n4_4 PTL_M3
Xn4_t4 n4_4 n4_5 PTL_M3
Xn4_t5 n4_5 n4_6 PTL_M3
Xn4_t6 n4_6 n4_7 PTL_M3
Xn4_t7 n4_7 n4_8 PTL_M3
Xn4_t8 n4_8 n4_9 PTL_M3
Xn4_t9 n4_9 n4_10 PTL_M3
Xn4_t10 n4_10 n4_11 PTL_M3
Xn4_t11 n4_11 n4_12 PTL_M3
Xn4_t12 n4_12 n4_13 PTL_M3
Xn4_t13 n4_13 n4_14 PTL_M3
Xn4_t14 n4_14 n4_15 PTL_M3
Xn4_t15 n4_15 n4_16 PTL_M3
Xn4_t16 n4_16 n4_17 PTL_M3
Xn4_t17 n4_17 n4_18 PTL_M3
Xn4_t18 n4_18 n4_19 PTL_M3
Xn4_t19 n4_19 n4_20 PTL_M3
Xn4_t20 n4_20 n4_21 PTL_M3
Xn4_t21 n4_21 n4_22 PTL_M3
Xn4_t22 n4_22 n4_23 BEND_PTL_M3
Xn4_t23 n4_23 n4_24 BEND_PTL_M3
Xn4_t24 n4_24 n4_o PTLCAP_M3
Xa1__spl_15_t0 a1__spl_15_i a1__spl_15_1 PTLCAP_M3
Xa1__spl_15_t1 a1__spl_15_1 a1__spl_15_2 PTL_M3
Xa1__spl_15_t2 a1__spl_15_2 a1__spl_15_3 PTL_M3
Xa1__spl_15_t3 a1__spl_15_3 a1__spl_15_4 BEND_PTL_M3
Xa1__spl_15_t4 a1__spl_15_4 a1__spl_15_5 PTL_M3
Xa1__spl_15_t5 a1__spl_15_5 a1__spl_15_6 PTL_M3
Xa1__spl_15_t6 a1__spl_15_6 a1__spl_15_7 PTL_M3
Xa1__spl_15_t7 a1__spl_15_7 a1__spl_15_8 PTL_M3
Xa1__spl_15_t8 a1__spl_15_8 a1__spl_15_9 PTL_M3
Xa1__spl_15_t9 a1__spl_15_9 a1__spl_15_10 PTL_M3
Xa1__spl_15_t10 a1__spl_15_10 a1__spl_15_11 PTL_M3
Xa1__spl_15_t11 a1__spl_15_11 a1__spl_15_12 PTL_M3
Xa1__spl_15_t12 a1__spl_15_12 a1__spl_15_13 PTL_M3
Xa1__spl_15_t13 a1__spl_15_13 a1__spl_15_14 PTL_M3
Xa1__spl_15_t14 a1__spl_15_14 a1__spl_15_15 PTL_M3
Xa1__spl_15_t15 a1__spl_15_15 a1__spl_15_16 BEND_PTL_M3
Xa1__spl_15_t16 a1__spl_15_16 a1__spl_15_17 PTL_M3
Xa1__spl_15_t17 a1__spl_15_17 a1__spl_15_18 PTL_M3
Xa1__spl_15_t18 a1__spl_15_18 a1__spl_15_19 PTL_M3
Xa1__spl_15_t19 a1__spl_15_19 a1__spl_15_20 PTL_M3
Xa1__spl_15_t20 a1__spl_15_20 a1__spl_15_21 PTL_M3
Xa1__spl_15_t21 a1__spl_15_21 a1__spl_15_22 PTL_M3
Xa1__spl_15_t22 a1__spl_15_22 a1__spl_15_23 PTL_M3
Xa1__spl_15_t23 a1__spl_15_23 a1__spl_15_24 PTL_M3
Xa1__spl_15_t24 a1__spl_15_24 a1__spl_15_25 BEND_PTL_M3
Xa1__spl_15_t25 a1__spl_15_25 a1__spl_15_o PTLCAP_M3
Xn4__spl_8__ff_1_t0 n4__spl_8__ff_1_i n4__spl_8__ff_1_1 PTLCAP_M3
Xn4__spl_8__ff_1_t1 n4__spl_8__ff_1_1 n4__spl_8__ff_1_2 BEND_PTL_M3
Xn4__spl_8__ff_1_t2 n4__spl_8__ff_1_2 n4__spl_8__ff_1_3 PTL_M3
Xn4__spl_8__ff_1_t3 n4__spl_8__ff_1_3 n4__spl_8__ff_1_4 PTL_M3
Xn4__spl_8__ff_1_t4 n4__spl_8__ff_1_4 n4__spl_8__ff_1_5 PTL_M3
Xn4__spl_8__ff_1_t5 n4__spl_8__ff_1_5 n4__spl_8__ff_1_6 PTL_M3
Xn4__spl_8__ff_1_t6 n4__spl_8__ff_1_6 n4__spl_8__ff_1_7 PTL_M3
Xn4__spl_8__ff_1_t7 n4__spl_8__ff_1_7 n4__spl_8__ff_1_8 PTL_M3
Xn4__spl_8__ff_1_t8 n4__spl_8__ff_1_8 n4__spl_8__ff_1_9 PTL_M3
Xn4__spl_8__ff_1_t9 n4__spl_8__ff_1_9 n4__spl_8__ff_1_10 PTL_M3
Xn4__spl_8__ff_1_t10 n4__spl_8__ff_1_10 n4__spl_8__ff_1_11 BEND_PTL_M3
Xn4__spl_8__ff_1_t11 n4__spl_8__ff_1_11 n4__spl_8__ff_1_12 PTL_M3
Xn4__spl_8__ff_1_t12 n4__spl_8__ff_1_12 n4__spl_8__ff_1_13 PTL_M3
Xn4__spl_8__ff_1_t13 n4__spl_8__ff_1_13 n4__spl_8__ff_1_14 PTL_M3
Xn4__spl_8__ff_1_t14 n4__spl_8__ff_1_14 n4__spl_8__ff_1_15 PTL_M3
Xn4__spl_8__ff_1_t15 n4__spl_8__ff_1_15 n4__spl_8__ff_1_16 PTL_M3
Xn4__spl_8__ff_1_t16 n4__spl_8__ff_1_16 n4__spl_8__ff_1_17 PTL_M3
Xn4__spl_8__ff_1_t17 n4__spl_8__ff_1_17 n4__spl_8__ff_1_18 PTL_M3
Xn4__spl_8__ff_1_t18 n4__spl_8__ff_1_18 n4__spl_8__ff_1_19 PTL_M3
Xn4__spl_8__ff_1_t19 n4__spl_8__ff_1_19 n4__spl_8__ff_1_20 PTL_M3
Xn4__spl_8__ff_1_t20 n4__spl_8__ff_1_20 n4__spl_8__ff_1_21 PTL_M3
Xn4__spl_8__ff_1_t21 n4__spl_8__ff_1_21 n4__spl_8__ff_1_22 PTL_M3
Xn4__spl_8__ff_1_t22 n4__spl_8__ff_1_22 n4__spl_8__ff_1_23 PTL_M3
Xn4__spl_8__ff_1_t23 n4__spl_8__ff_1_23 n4__spl_8__ff_1_24 PTL_M3
Xn4__spl_8__ff_1_t24 n4__spl_8__ff_1_24 n4__spl_8__ff_1_25 PTL_M3
Xn4__spl_8__ff_1_t25 n4__spl_8__ff_1_25 n4__spl_8__ff_1_26 PTL_M3
Xn4__spl_8__ff_1_t26 n4__spl_8__ff_1_26 n4__spl_8__ff_1_27 PTL_M3
Xn4__spl_8__ff_1_t27 n4__spl_8__ff_1_27 n4__spl_8__ff_1_o PTLCAP_M3
Xb0__spl_5_t0 b0__spl_5_i b0__spl_5_1 PTLCAP_M3
Xb0__spl_5_t1 b0__spl_5_1 b0__spl_5_2 BEND_PTL_M3
Xb0__spl_5_t2 b0__spl_5_2 b0__spl_5_3 PTL_M3
Xb0__spl_5_t3 b0__spl_5_3 b0__spl_5_4 BEND_PTL_M3
Xb0__spl_5_t4 b0__spl_5_4 b0__spl_5_5 PTL_M3
Xb0__spl_5_t5 b0__spl_5_5 b0__spl_5_6 PTL_M3
Xb0__spl_5_t6 b0__spl_5_6 b0__spl_5_7 PTL_M3
Xb0__spl_5_t7 b0__spl_5_7 b0__spl_5_8 PTL_M3
Xb0__spl_5_t8 b0__spl_5_8 b0__spl_5_9 PTL_M3
Xb0__spl_5_t9 b0__spl_5_9 b0__spl_5_10 PTL_M3
Xb0__spl_5_t10 b0__spl_5_10 b0__spl_5_11 BEND_PTL_M3
Xb0__spl_5_t11 b0__spl_5_11 b0__spl_5_12 PTL_M3
Xb0__spl_5_t12 b0__spl_5_12 b0__spl_5_13 PTL_M3
Xb0__spl_5_t13 b0__spl_5_13 b0__spl_5_14 PTL_M3
Xb0__spl_5_t14 b0__spl_5_14 b0__spl_5_15 PTL_M3
Xb0__spl_5_t15 b0__spl_5_15 b0__spl_5_16 PTL_M3
Xb0__spl_5_t16 b0__spl_5_16 b0__spl_5_17 PTL_M3
Xb0__spl_5_t17 b0__spl_5_17 b0__spl_5_18 PTL_M3
Xb0__spl_5_t18 b0__spl_5_18 b0__spl_5_19 PTL_M3
Xb0__spl_5_t19 b0__spl_5_19 b0__spl_5_20 PTL_M3
Xb0__spl_5_t20 b0__spl_5_20 b0__spl_5_21 PTL_M3
Xb0__spl_5_t21 b0__spl_5_21 b0__spl_5_22 PTL_M3
Xb0__spl_5_t22 b0__spl_5_22 b0__spl_5_23 PTL_M3
Xb0__spl_5_t23 b0__spl_5_23 b0__spl_5_24 PTL_M3
Xb0__spl_5_t24 b0__spl_5_24 b0__spl_5_25 PTL_M3
Xb0__spl_5_t25 b0__spl_5_25 b0__spl_5_26 PTL_M3
Xb0__spl_5_t26 b0__spl_5_26 b0__spl_5_27 PTL_M3
Xb0__spl_5_t27 b0__spl_5_27 b0__spl_5_28 PTL_M3
Xb0__spl_5_t28 b0__spl_5_28 b0__spl_5_29 PTL_M3
Xb0__spl_5_t29 b0__spl_5_29 b0__spl_5_30 PTL_M3
Xb0__spl_5_t30 b0__spl_5_30 b0__spl_5_31 BEND_PTL_M3
Xb0__spl_5_t31 b0__spl_5_31 b0__spl_5_o PTLCAP_M3
Xclk_spine_1_t0 clk_spine_1_i clk_spine_1_1 PTLCAP_M3
Xclk_spine_1_t1 clk_spine_1_1 clk_spine_1_2 PTL_M3
Xclk_spine_1_t2 clk_spine_1_2 clk_spine_1_3 PTL_M3
Xclk_spine_1_t3 clk_spine_1_3 clk_spine_1_4 BEND_PTL_M3
Xclk_spine_1_t4 clk_spine_1_4 clk_spine_1_5 PTL_M3
Xclk_spine_1_t5 clk_spine_1_5 clk_spine_1_6 PTL_M3
Xclk_spine_1_t6 clk_spine_1_6 clk_spine_1_7 PTL_M3
Xclk_spine_1_t7 clk_spine_1_7 clk_spine_1_8 PTL_M3
Xclk_spine_1_t8 clk_spine_1_8 clk_spine_1_9 PTL_M3
Xclk_spine_1_t9 clk_spine_1_9 clk_spine_1_10 PTL_M3
Xclk_spine_1_t10 clk_spine_1_10 clk_spine_1_11 PTL_M3
Xclk_spine_1_t11 clk_spine_1_11 clk_spine_1_12 PTL_M3
Xclk_spine_1_t12 clk_spine_1_12 clk_spine_1_13 PTL_M3
Xclk_spine_1_t13 clk_spine_1_13 clk_spine_1_14 PTL_M3
Xclk_spine_1_t14 clk_spine_1_14 clk_spine_1_15 PTL_M3
Xclk_spine_1_t15 clk_spine_1_15 clk_spine_1_16 PTL_M3
Xclk_spine_1_t16 clk_spine_1_16 clk_spine_1_17 PTL_M3
Xclk_spine_1_t17 clk_spine_1_17 clk_spine_1_18 PTL_M3
Xclk_spine_1_t18 clk_spine_1_18 clk_spine_1_19 PTL_M3
Xclk_spine_1_t19 clk_spine_1_19 clk_spine_1_20 PTL_M3
Xclk_spine_1_t20 clk_spine_1_20 clk_spine_1_21 PTL_M3
Xclk_spine_1_t21 clk_spine_1_21 clk_spine_1_22 PTL_M3
Xclk_spine_1_t22 clk_spine_1_22 clk_spine_1_23 PTL_M3
Xclk_spine_1_t23 clk_spine_1_23 clk_spine_1_24 PTL_M3
Xclk_spine_1_t24 clk_spine_1_24 clk_spine_1_25 BEND_PTL_M3
Xclk_spine_1_t25 clk_spine_1_25 clk_spine_1_o PTLCAP_M3
Xa1__spl_16_t0 a1__spl_16_i a1__spl_16_1 PTLCAP_M3
Xa1__spl_16_t1 a1__spl_16_1 a1__spl_16_2 BEND_PTL_M3
Xa1__spl_16_t2 a1__spl_16_2 a1__spl_16_3 PTL_M3
Xa1__spl_16_t3 a1__spl_16_3 a1__spl_16_4 PTL_M3
Xa1__spl_16_t4 a1__spl_16_4 a1__spl_16_5 PTL_M3
Xa1__spl_16_t5 a1__spl_16_5 a1__spl_16_6 PTL_M3
Xa1__spl_16_t6 a1__spl_16_6 a1__spl_16_7 PTL_M3
Xa1__spl_16_t7 a1__spl_16_7 a1__spl_16_8 PTL_M3
Xa1__spl_16_t8 a1__spl_16_8 a1__spl_16_9 PTL_M3
Xa1__spl_16_t9 a1__spl_16_9 a1__spl_16_10 PTL_M3
Xa1__spl_16_t10 a1__spl_16_10 a1__spl_16_11 PTL_M3
Xa1__spl_16_t11 a1__spl_16_11 a1__spl_16_12 PTL_M3
Xa1__spl_16_t12 a1__spl_16_12 a1__spl_16_13 PTL_M3
Xa1__spl_16_t13 a1__spl_16_13 a1__spl_16_14 PTL_M3
Xa1__spl_16_t14 a1__spl_16_14 a1__spl_16_15 PTL_M3
Xa1__spl_16_t15 a1__spl_16_15 a1__spl_16_16 PTL_M3
Xa1__spl_16_t16 a1__spl_16_16 a1__spl_16_17 PTL_M3
Xa1__spl_16_t17 a1__spl_16_17 a1__spl_16_18 PTL_M3
Xa1__spl_16_t18 a1__spl_16_18 a1__spl_16_19 PTL_M3
Xa1__spl_16_t19 a1__spl_16_19 a1__spl_16_20 PTL_M3
Xa1__spl_16_t20 a1__spl_16_20 a1__spl_16_21 PTL_M3
Xa1__spl_16_t21 a1__spl_16_21 a1__spl_16_22 BEND_PTL_M3
Xa1__spl_16_t22 a1__spl_16_22 a1__spl_16_23 PTL_M3
Xa1__spl_16_t23 a1__spl_16_23 a1__spl_16_24 PTL_M3
Xa1__spl_16_t24 a1__spl_16_24 a1__spl_16_25 BEND_PTL_M3
Xa1__spl_16_t25 a1__spl_16_25 a1__spl_16_26 PTL_M3
Xa1__spl_16_t26 a1__spl_16_26 a1__spl_16_27 PTL_M3
Xa1__spl_16_t27 a1__spl_16_27 a1__spl_16_28 PTL_M3
Xa1__spl_16_t28 a1__spl_16_28 a1__spl_16_29 PTL_M3
Xa1__spl_16_t29 a1__spl_16_29 a1__spl_16_30 BEND_PTL_M3
Xa1__spl_16_t30 a1__spl_16_30 a1__spl_16_31 PTL_M3
Xa1__spl_16_t31 a1__spl_16_31 a1__spl_16_32 PTL_M3
Xa1__spl_16_t32 a1__spl_16_32 a1__spl_16_33 PTL_M3
Xa1__spl_16_t33 a1__spl_16_33 a1__spl_16_34 PTL_M3
Xa1__spl_16_t34 a1__spl_16_34 a1__spl_16_35 PTL_M3
Xa1__spl_16_t35 a1__spl_16_35 a1__spl_16_36 PTL_M3
Xa1__spl_16_t36 a1__spl_16_36 a1__spl_16_37 PTL_M3
Xa1__spl_16_t37 a1__spl_16_37 a1__spl_16_38 BEND_PTL_M3
Xa1__spl_16_t38 a1__spl_16_38 a1__spl_16_o PTLCAP_M3
Xp0__out_entry_1_t0 p0__out_entry_1_i p0__out_entry_1_1 PTLCAP_M3
Xp0__out_entry_1_t1 p0__out_entry_1_1 p0__out_entry_1_2 PTL_M3
Xp0__out_entry_1_t2 p0__out_entry_1_2 p0__out_entry_1_3 PTL_M3
Xp0__out_entry_1_t3 p0__out_entry_1_3 p0__out_entry_1_4 BEND_PTL_M3
Xp0__out_entry_1_t4 p0__out_entry_1_4 p0__out_entry_1_5 PTL_M3
Xp0__out_entry_1_t5 p0__out_entry_1_5 p0__out_entry_1_6 BEND_PTL_M3
Xp0__out_entry_1_t6 p0__out_entry_1_6 p0__out_entry_1_7 PTL_M3
Xp0__out_entry_1_t7 p0__out_entry_1_7 p0__out_entry_1_8 PTL_M3
Xp0__out_entry_1_t8 p0__out_entry_1_8 p0__out_entry_1_9 PTL_M3
Xp0__out_entry_1_t9 p0__out_entry_1_9 p0__out_entry_1_10 PTL_M3
Xp0__out_entry_1_t10 p0__out_entry_1_10 p0__out_entry_1_11 PTL_M3
Xp0__out_entry_1_t11 p0__out_entry_1_11 p0__out_entry_1_12 PTL_M3
Xp0__out_entry_1_t12 p0__out_entry_1_12 p0__out_entry_1_13 PTL_M3
Xp0__out_entry_1_t13 p0__out_entry_1_13 p0__out_entry_1_14 PTL_M3
Xp0__out_entry_1_t14 p0__out_entry_1_14 p0__out_entry_1_15 PTL_M3
Xp0__out_entry_1_t15 p0__out_entry_1_15 p0__out_entry_1_16 PTL_M3
Xp0__out_entry_1_t16 p0__out_entry_1_16 p0__out_entry_1_17 PTL_M3
Xp0__out_entry_1_t17 p0__out_entry_1_17 p0__out_entry_1_18 PTL_M3
Xp0__out_entry_1_t18 p0__out_entry_1_18 p0__out_entry_1_19 BEND_PTL_M3
Xp0__out_entry_1_t19 p0__out_entry_1_19 p0__out_entry_1_20 PTL_M3
Xp0__out_entry_1_t20 p0__out_entry_1_20 p0__out_entry_1_21 PTL_M3
Xp0__out_entry_1_t21 p0__out_entry_1_21 p0__out_entry_1_22 PTL_M3
Xp0__out_entry_1_t22 p0__out_entry_1_22 p0__out_entry_1_23 PTL_M3
Xp0__out_entry_1_t23 p0__out_entry_1_23 p0__out_entry_1_24 PTL_M3
Xp0__out_entry_1_t24 p0__out_entry_1_24 p0__out_entry_1_25 BEND_PTL_M3
Xp0__out_entry_1_t25 p0__out_entry_1_25 p0__out_entry_1_26 PTL_M3
Xp0__out_entry_1_t26 p0__out_entry_1_26 p0__out_entry_1_27 PTL_M3
Xp0__out_entry_1_t27 p0__out_entry_1_27 p0__out_entry_1_28 PTL_M3
Xp0__out_entry_1_t28 p0__out_entry_1_28 p0__out_entry_1_o PTLCAP_M3
Xn6__spl_3_t0 n6__spl_3_i n6__spl_3_1 PTLCAP_M3
Xn6__spl_3_t1 n6__spl_3_1 n6__spl_3_2 PTL_M3
Xn6__spl_3_t2 n6__spl_3_2 n6__spl_3_3 PTL_M3
Xn6__spl_3_t3 n6__spl_3_3 n6__spl_3_4 PTL_M3
Xn6__spl_3_t4 n6__spl_3_4 n6__spl_3_5 PTL_M3
Xn6__spl_3_t5 n6__spl_3_5 n6__spl_3_6 PTL_M3
Xn6__spl_3_t6 n6__spl_3_6 n6__spl_3_7 BEND_PTL_M3
Xn6__spl_3_t7 n6__spl_3_7 n6__spl_3_8 PTL_M3
Xn6__spl_3_t8 n6__spl_3_8 n6__spl_3_9 PTL_M3
Xn6__spl_3_t9 n6__spl_3_9 n6__spl_3_10 PTL_M3
Xn6__spl_3_t10 n6__spl_3_10 n6__spl_3_11 PTL_M3
Xn6__spl_3_t11 n6__spl_3_11 n6__spl_3_12 PTL_M3
Xn6__spl_3_t12 n6__spl_3_12 n6__spl_3_13 PTL_M3
Xn6__spl_3_t13 n6__spl_3_13 n6__spl_3_14 PTL_M3
Xn6__spl_3_t14 n6__spl_3_14 n6__spl_3_15 PTL_M3
Xn6__spl_3_t15 n6__spl_3_15 n6__spl_3_16 PTL_M3
Xn6__spl_3_t16 n6__spl_3_16 n6__spl_3_17 PTL_M3
Xn6__spl_3_t17 n6__spl_3_17 n6__spl_3_18 PTL_M3
Xn6__spl_3_t18 n6__spl_3_18 n6__spl_3_19 PTL_M3
Xn6__spl_3_t19 n6__spl_3_19 n6__spl_3_20 PTL_M3
Xn6__spl_3_t20 n6__spl_3_20 n6__spl_3_21 PTL_M3
Xn6__spl_3_t21 n6__spl_3_21 n6__spl_3_22 PTL_M3
Xn6__spl_3_t22 n6__spl_3_22 n6__spl_3_23 PTL_M3
Xn6__spl_3_t23 n6__spl_3_23 n6__spl_3_24 PTL_M3
Xn6__spl_3_t24 n6__spl_3_24 n6__spl_3_25 PTL_M3
Xn6__spl_3_t25 n6__spl_3_25 n6__spl_3_26 PTL_M3
Xn6__spl_3_t26 n6__spl_3_26 n6__spl_3_27 BEND_PTL_M3
Xn6__spl_3_t27 n6__spl_3_27 n6__spl_3_28 PTL_M3
Xn6__spl_3_t28 n6__spl_3_28 n6__spl_3_o PTLCAP_M3
Xb1__spl_1_t0 b1__spl_1_i b1__spl_1_1 PTLCAP_M3
Xb1__spl_1_t1 b1__spl_1_1 b1__spl_1_2 PTL_M3
Xb1__spl_1_t2 b1__spl_1_2 b1__spl_1_3 PTL_M3
Xb1__spl_1_t3 b1__spl_1_3 b1__spl_1_4 PTL_M3
Xb1__spl_1_t4 b1__spl_1_4 b1__spl_1_5 PTL_M3
Xb1__spl_1_t5 b1__spl_1_5 b1__spl_1_6 PTL_M3
Xb1__spl_1_t6 b1__spl_1_6 b1__spl_1_7 BEND_PTL_M3
Xb1__spl_1_t7 b1__spl_1_7 b1__spl_1_8 PTL_M3
Xb1__spl_1_t8 b1__spl_1_8 b1__spl_1_9 PTL_M3
Xb1__spl_1_t9 b1__spl_1_9 b1__spl_1_10 BEND_PTL_M3
Xb1__spl_1_t10 b1__spl_1_10 b1__spl_1_11 PTL_M3
Xb1__spl_1_t11 b1__spl_1_11 b1__spl_1_12 PTL_M3
Xb1__spl_1_t12 b1__spl_1_12 b1__spl_1_13 PTL_M3
Xb1__spl_1_t13 b1__spl_1_13 b1__spl_1_14 PTL_M3
Xb1__spl_1_t14 b1__spl_1_14 b1__spl_1_15 PTL_M3
Xb1__spl_1_t15 b1__spl_1_15 b1__spl_1_16 PTL_M3
Xb1__spl_1_t16 b1__spl_1_16 b1__spl_1_17 PTL_M3
Xb1__spl_1_t17 b1__spl_1_17 b1__spl_1_18 PTL_M3
Xb1__spl_1_t18 b1__spl_1_18 b1__spl_1_19 PTL_M3
Xb1__spl_1_t19 b1__spl_1_19 b1__spl_1_20 PTL_M3
Xb1__spl_1_t20 b1__spl_1_20 b1__spl_1_21 PTL_M3
Xb1__spl_1_t21 b1__spl_1_21 b1__spl_1_22 PTL_M3
Xb1__spl_1_t22 b1__spl_1_22 b1__spl_1_23 PTL_M3
Xb1__spl_1_t23 b1__spl_1_23 b1__spl_1_24 PTL_M3
Xb1__spl_1_t24 b1__spl_1_24 b1__spl_1_25 PTL_M3
Xb1__spl_1_t25 b1__spl_1_25 b1__spl_1_26 PTL_M3
Xb1__spl_1_t26 b1__spl_1_26 b1__spl_1_27 BEND_PTL_M3
Xb1__spl_1_t27 b1__spl_1_27 b1__spl_1_28 PTL_M3
Xb1__spl_1_t28 b1__spl_1_28 b1__spl_1_29 PTL_M3
Xb1__spl_1_t29 b1__spl_1_29 b1__spl_1_30 PTL_M3
Xb1__spl_1_t30 b1__spl_1_30 b1__spl_1_31 PTL_M3
Xb1__spl_1_t31 b1__spl_1_31 b1__spl_1_32 PTL_M3
Xb1__spl_1_t32 b1__spl_1_32 b1__spl_1_33 PTL_M3
Xb1__spl_1_t33 b1__spl_1_33 b1__spl_1_34 PTL_M3
Xb1__spl_1_t34 b1__spl_1_34 b1__spl_1_35 PTL_M3
Xb1__spl_1_t35 b1__spl_1_35 b1__spl_1_36 PTL_M3
Xb1__spl_1_t36 b1__spl_1_36 b1__spl_1_37 PTL_M3
Xb1__spl_1_t37 b1__spl_1_37 b1__spl_1_38 PTL_M3
Xb1__spl_1_t38 b1__spl_1_38 b1__spl_1_39 PTL_M3
Xb1__spl_1_t39 b1__spl_1_39 b1__spl_1_40 PTL_M3
Xb1__spl_1_t40 b1__spl_1_40 b1__spl_1_41 PTL_M3
Xb1__spl_1_t41 b1__spl_1_41 b1__spl_1_42 PTL_M3
Xb1__spl_1_t42 b1__spl_1_42 b1__spl_1_43 PTL_M3
Xb1__spl_1_t43 b1__spl_1_43 b1__spl_1_44 PTL_M3
Xb1__spl_1_t44 b1__spl_1_44 b1__spl_1_45 PTL_M3
Xb1__spl_1_t45 b1__spl_1_45 b1__spl_1_46 BEND_PTL_M3
Xb1__spl_1_t46 b1__spl_1_46 b1__spl_1_47 PTL_M3
Xb1__spl_1_t47 b1__spl_1_47 b1__spl_1_48 PTL_M3
Xb1__spl_1_t48 b1__spl_1_48 b1__spl_1_49 PTL_M3
Xb1__spl_1_t49 b1__spl_1_49 b1__spl_1_50 PTL_M3
Xb1__spl_1_t50 b1__spl_1_50 b1__spl_1_51 PTL_M3
Xb1__spl_1_t51 b1__spl_1_51 b1__spl_1_52 PTL_M3
Xb1__spl_1_t52 b1__spl_1_52 b1__spl_1_53 PTL_M3
Xb1__spl_1_t53 b1__spl_1_53 b1__spl_1_54 PTL_M3
Xb1__spl_1_t54 b1__spl_1_54 b1__spl_1_55 PTL_M3
Xb1__spl_1_t55 b1__spl_1_55 b1__spl_1_56 BEND_PTL_M3
Xb1__spl_1_t56 b1__spl_1_56 b1__spl_1_57 PTL_M3
Xb1__spl_1_t57 b1__spl_1_57 b1__spl_1_58 BEND_PTL_M3
Xb1__spl_1_t58 b1__spl_1_58 b1__spl_1_o PTLCAP_M3
Xclk_row_2_t0 clk_row_2_i clk_row_2_1 PTLCAP_M3
Xclk_row_2_t1 clk_row_2_1 clk_row_2_2 PTL_M3
Xclk_row_2_t2 clk_row_2_2 clk_row_2_3 PTL_M3
Xclk_row_2_t3 clk_row_2_3 clk_row_2_4 BEND_PTL_M3
Xclk_row_2_t4 clk_row_2_4 clk_row_2_5 PTL_M3
Xclk_row_2_t5 clk_row_2_5 clk_row_2_6 PTL_M3
Xclk_row_2_t6 clk_row_2_6 clk_row_2_7 PTL_M3
Xclk_row_2_t7 clk_row_2_7 clk_row_2_8 PTL_M3
Xclk_row_2_t8 clk_row_2_8 clk_row_2_9 PTL_M3
Xclk_row_2_t9 clk_row_2_9 clk_row_2_10 PTL_M3
Xclk_row_2_t10 clk_row_2_10 clk_row_2_11 PTL_M3
Xclk_row_2_t11 clk_row_2_11 clk_row_2_12 PTL_M3
Xclk_row_2_t12 clk_row_2_12 clk_row_2_13 BEND_PTL_M3
Xclk_row_2_t13 clk_row_2_13 clk_row_2_14 PTL_M3
Xclk_row_2_t14 clk_row_2_14 clk_row_2_15 PTL_M3
Xclk_row_2_t15 clk_row_2_15 clk_row_2_16 PTL_M3
Xclk_row_2_t16 clk_row_2_16 clk_row_2_17 PTL_M3
Xclk_row_2_t17 clk_row_2_17 clk_row_2_18 PTL_M3
Xclk_row_2_t18 clk_row_2_18 clk_row_2_19 PTL_M3
Xclk_row_2_t19 clk_row_2_19 clk_row_2_20 PTL_M3
Xclk_row_2_t20 clk_row_2_20 clk_row_2_21 PTL_M3
Xclk_row_2_t21 clk_row_2_21 clk_row_2_22 PTL_M3
Xclk_row_2_t22 clk_row_2_22 clk_row_2_23 PTL_M3
Xclk_row_2_t23 clk_row_2_23 clk_row_2_24 PTL_M3
Xclk_row_2_t24 clk_row_2_24 clk_row_2_25 PTL_M3
Xclk_row_2_t25 clk_row_2_25 clk_row_2_26 PTL_M3
Xclk_row_2_t26 clk_row_2_26 clk_row_2_27 PTL_M3
Xclk_row_2_t27 clk_row_2_27 clk_row_2_28 BEND_PTL_M3
Xclk_row_2_t28 clk_row_2_28 clk_row_2_29 PTL_M3
Xclk_row_2_t29 clk_row_2_29 clk_row_2_30 PTL_M3
Xclk_row_2_t30 clk_row_2_30 clk_row_2_31 PTL_M3
Xclk_row_2_t31 clk_row_2_31 clk_row_2_32 PTL_M3
Xclk_row_2_t32 clk_row_2_32 clk_row_2_33 PTL_M3
Xclk_row_2_t33 clk_row_2_33 clk_row_2_34 PTL_M3
Xclk_row_2_t34 clk_row_2_34 clk_row_2_35 PTL_M3
Xclk_row_2_t35 clk_row_2_35 clk_row_2_36 PTL_M3
Xclk_row_2_t36 clk_row_2_36 clk_row_2_37 PTL_M3
Xclk_row_2_t37 clk_row_2_37 clk_row_2_38 PTL_M3
Xclk_row_2_t38 clk_row_2_38 clk_row_2_39 PTL_M3
Xclk_row_2_t39 clk_row_2_39 clk_row_2_40 PTL_M3
Xclk_row_2_t40 clk_row_2_40 clk_row_2_41 PTL_M3
Xclk_row_2_t41 clk_row_2_41 clk_row_2_42 PTL_M3
Xclk_row_2_t42 clk_row_2_42 clk_row_2_43 PTL_M3
Xclk_row_2_t43 clk_row_2_43 clk_row_2_44 PTL_M3
Xclk_row_2_t44 clk_row_2_44 clk_row_2_45 BEND_PTL_M3
Xclk_row_2_t45 clk_row_2_45 clk_row_2_46 PTL_M3
Xclk_row_2_t46 clk_row_2_46 clk_row_2_47 PTL_M3
Xclk_row_2_t47 clk_row_2_47 clk_row_2_48 PTL_M3
Xclk_row_2_t48 clk_row_2_48 clk_row_2_49 PTL_M3
Xclk_row_2_t49 clk_row_2_49 clk_row_2_50 PTL_M3
Xclk_row_2_t50 clk_row_2_50 clk_row_2_51 PTL_M3
Xclk_row_2_t51 clk_row_2_51 clk_row_2_52 PTL_M3
Xclk_row_2_t52 clk_row_2_52 clk_row_2_53 PTL_M3
Xclk_row_2_t53 clk_row_2_53 clk_row_2_54 PTL_M3
Xclk_row_2_t54 clk_row_2_54 clk_row_2_55 PTL_M3
Xclk_row_2_t55 clk_row_2_55 clk_row_2_56 PTL_M3
Xclk_row_2_t56 clk_row_2_56 clk_row_2_57 PTL_M3
Xclk_row_2_t57 clk_row_2_57 clk_row_2_58 PTL_M3
Xclk_row_2_t58 clk_row_2_58 clk_row_2_59 PTL_M3
Xclk_row_2_t59 clk_row_2_59 clk_row_2_60 PTL_M3
Xclk_row_2_t60 clk_row_2_60 clk_row_2_61 PTL_M3
Xclk_row_2_t61 clk_row_2_61 clk_row_2_62 PTL_M3
Xclk_row_2_t62 clk_row_2_62 clk_row_2_o PTLCAP_M3
Xn3__spl_10_t0 n3__spl_10_i n3__spl_10_1 PTLCAP_M3
Xn3__spl_10_t1 n3__spl_10_1 n3__spl_10_2 PTL_M3
Xn3__spl_10_t2 n3__spl_10_2 n3__spl_10_3 PTL_M3
Xn3__spl_10_t3 n3__spl_10_3 n3__spl_10_4 BEND_PTL_M3
Xn3__spl_10_t4 n3__spl_10_4 n3__spl_10_5 PTL_M3
Xn3__spl_10_t5 n3__spl_10_5 n3__spl_10_6 PTL_M3
Xn3__spl_10_t6 n3__spl_10_6 n3__spl_10_7 PTL_M3
Xn3__spl_10_t7 n3__spl_10_7 n3__spl_10_8 PTL_M3
Xn3__spl_10_t8 n3__spl_10_8 n3__spl_10_9 PTL_M3
Xn3__spl_10_t9 n3__spl_10_9 n3__spl_10_10 PTL_M3
Xn3__spl_10_t10 n3__spl_10_10 n3__spl_10_11 PTL_M3
Xn3__spl_10_t11 n3__spl_10_11 n3__spl_10_12 PTL_M3
Xn3__spl_10_t12 n3__spl_10_12 n3__spl_10_13 PTL_M3
Xn3__spl_10_t13 n3__spl_10_13 n3__spl_10_14 PTL_M3
Xn3__spl_10_t14 n3__spl_10_14 n3__spl_10_15 PTL_M3
Xn3__spl_10_t15 n3__spl_10_15 n3__spl_10_16 PTL_M3
Xn3__spl_10_t16 n3__spl_10_16 n3__spl_10_17 PTL_M3
Xn3__spl_10_t17 n3__spl_10_17 n3__spl_10_18 PTL_M3
Xn3__spl_10_t18 n3__spl_10_18 n3__spl_10_19 PTL_M3
Xn3__spl_10_t19 n3__spl_10_19 n3__spl_10_20 PTL_M3
Xn3__spl_10_t20 n3__spl_10_20 n3__spl_10_21 PTL_M3
Xn3__spl_10_t21 n3__spl_10_21 n3__spl_10_22 PTL_M3
Xn3__spl_10_t22 n3__spl_10_22 n3__spl_10_23 PTL_M3
Xn3__spl_10_t23 n3__spl_10_23 n3__spl_10_24 PTL_M3
Xn3__spl_10_t24 n3__spl_10_24 n3__spl_10_25 BEND_PTL_M3
Xn3__spl_10_t25 n3__spl_10_25 n3__spl_10_26 PTL_M3
Xn3__spl_10_t26 n3__spl_10_26 n3__spl_10_27 PTL_M3
Xn3__spl_10_t27 n3__spl_10_27 n3__spl_10_28 PTL_M3
Xn3__spl_10_t28 n3__spl_10_28 n3__spl_10_29 PTL_M3
Xn3__spl_10_t29 n3__spl_10_29 n3__spl_10_30 PTL_M3
Xn3__spl_10_t30 n3__spl_10_30 n3__spl_10_31 PTL_M3
Xn3__spl_10_t31 n3__spl_10_31 n3__spl_10_32 PTL_M3
Xn3__spl_10_t32 n3__spl_10_32 n3__spl_10_33 PTL_M3
Xn3__spl_10_t33 n3__spl_10_33 n3__spl_10_o PTLCAP_M3
Xp0_t0 p0_i p0_1 PTLCAP_M3
Xp0_t1 p0_1 p0_2 BEND_PTL_M3
Xp0_t2 p0_2 p0_3 PTL_M3
Xp0_t3 p0_3 p0_4 PTL_M3
Xp0_t4 p0_4 p0_5 PTL_M3
Xp0_t5 p0_5 p0_6 PTL_M3
Xp0_t6 p0_6 p0_7 PTL_M3
Xp0_t7 p0_7 p0_8 PTL_M3
Xp0_t8 p0_8 p0_9 PTL_M3
Xp0_t9 p0_9 p0_10 PTL_M3
Xp0_t10 p0_10 p0_11 PTL_M3
Xp0_t11 p0_11 p0_12 PTL_M3
Xp0_t12 p0_12 p0_13 PTL_M3
Xp0_t13 p0_13 p0_14 PTL_M3
Xp0_t14 p0_14 p0_15 PTL_M3
Xp0_t15 p0_15 p0_16 PTL_M3
Xp0_t16 p0_16 p0_17 PTL_M3
Xp0_t17 p0_17 p0_18 PTL_M3
Xp0_t18 p0_18 p0_19 PTL_M3
Xp0_t19 p0_19 p0_20 PTL_M3
Xp0_t20 p0_20 p0_21 PTL_M3
Xp0_t21 p0_21 p0_22 PTL_M3
Xp0_t22 p0_22 p0_23 PTL_M3
Xp0_t23 p0_23 p0_24 PTL_M3
Xp0_t24 p0_24 p0_25 PTL_M3
Xp0_t25 p0_25 p0_26 PTL_M3
Xp0_t26 p0_26 p0_27 PTL_M3
Xp0_t27 p0_27 p0_28 PTL_M3
Xp0_t28 p0_28 p0_29 PTL_M3
Xp0_t29 p0_29 p0_30 BEND_PTL_M3
Xp0_t30 p0_30 p0_31 PTL_M3
Xp0_t31 p0_31 p0_32 PTL_M3
Xp0_t32 p0_32 p0_33 PTL_M3
Xp0_t33 p0_33 p0_34 PTL_M3
Xp0_t34 p0_34 p0_35 PTL_M3
Xp0_t35 p0_35 p0_36 PTL_M3
Xp0_t36 p0_36 p0_o PTLCAP_M3
Xp1_t0 p1_i p1_1 PTLCAP_M3
Xp1_t1 p1_1 p1_2 BEND_PTL_M3
Xp1_t2 p1_2 p1_3 PTL_M3
Xp1_t3 p1_3 p1_4 PTL_M3
Xp1_t4 p1_4 p1_5 PTL_M3
Xp1_t5 p1_5 p1_6 PTL_M3
Xp1_t6 p1_6 p1_7 PTL_M3
Xp1_t7 p1_7 p1_8 PTL_M3
Xp1_t8 p1_8 p1_9 PTL_M3
Xp1_t9 p1_9 p1_10 PTL_M3
Xp1_t10 p1_10 p1_11 BEND_PTL_M3
Xp1_t11 p1_11 p1_12 PTL_M3
Xp1_t12 p1_12 p1_13 PTL_M3
Xp1_t13 p1_13 p1_14 PTL_M3
Xp1_t14 p1_14 p1_15 PTL_M3
Xp1_t15 p1_15 p1_16 PTL_M3
Xp1_t16 p1_16 p1_17 PTL_M3
Xp1_t17 p1_17 p1_18 PTL_M3
Xp1_t18 p1_18 p1_19 PTL_M3
Xp1_t19 p1_19 p1_20 PTL_M3
Xp1_t20 p1_20 p1_21 PTL_M3
Xp1_t21 p1_21 p1_22 PTL_M3
Xp1_t22 p1_22 p1_23 PTL_M3
Xp1_t23 p1_23 p1_24 PTL_M3
Xp1_t24 p1_24 p1_25 PTL_M3
Xp1_t25 p1_25 p1_26 PTL_M3
Xp1_t26 p1_26 p1_27 PTL_M3
Xp1_t27 p1_27 p1_28 PTL_M3
Xp1_t28 p1_28 p1_29 PTL_M3
Xp1_t29 p1_29 p1_30 PTL_M3
Xp1_t30 p1_30 p1_31 PTL_M3
Xp1_t31 p1_31 p1_32 PTL_M3
Xp1_t32 p1_32 p1_33 PTL_M3
Xp1_t33 p1_33 p1_34 PTL_M3
Xp1_t34 p1_34 p1_35 PTL_M3
Xp1_t35 p1_35 p1_36 PTL_M3
Xp1_t36 p1_36 p1_37 PTL_M3
Xp1_t37 p1_37 p1_38 PTL_M3
Xp1_t38 p1_38 p1_39 PTL_M3
Xp1_t39 p1_39 p1_o PTLCAP_M3
Xp0__out_ff_2_t0 p0__out_ff_2_i p0__out_ff_2_1 PTLCAP_M3
Xp0__out_ff_2_t1 p0__out_ff_2_1 p0__out_ff_2_2 BEND_PTL_M3
Xp0__out_ff_2_t2 p0__out_ff_2_2 p0__out_ff_2_3 PTL_M3
Xp0__out_ff_2_t3 p0__out_ff_2_3 p0__out_ff_2_4 PTL_M3
Xp0__out_ff_2_t4 p0__out_ff_2_4 p0__out_ff_2_5 PTL_M3
Xp0__out_ff_2_t5 p0__out_ff_2_5 p0__out_ff_2_6 PTL_M3
Xp0__out_ff_2_t6 p0__out_ff_2_6 p0__out_ff_2_7 PTL_M3
Xp0__out_ff_2_t7 p0__out_ff_2_7 p0__out_ff_2_8 BEND_PTL_M3
Xp0__out_ff_2_t8 p0__out_ff_2_8 p0__out_ff_2_9 PTL_M3
Xp0__out_ff_2_t9 p0__out_ff_2_9 p0__out_ff_2_10 PTL_M3
Xp0__out_ff_2_t10 p0__out_ff_2_10 p0__out_ff_2_11 PTL_M3
Xp0__out_ff_2_t11 p0__out_ff_2_11 p0__out_ff_2_12 PTL_M3
Xp0__out_ff_2_t12 p0__out_ff_2_12 p0__out_ff_2_13 PTL_M3
Xp0__out_ff_2_t13 p0__out_ff_2_13 p0__out_ff_2_14 PTL_M3
Xp0__out_ff_2_t14 p0__out_ff_2_14 p0__out_ff_2_15 PTL_M3
Xp0__out_ff_2_t15 p0__out_ff_2_15 p0__out_ff_2_16 PTL_M3
Xp0__out_ff_2_t16 p0__out_ff_2_16 p0__out_ff_2_17 PTL_M3
Xp0__out_ff_2_t17 p0__out_ff_2_17 p0__out_ff_2_18 PTL_M3
Xp0__out_ff_2_t18 p0__out_ff_2_18 p0__out_ff_2_19 PTL_M3
Xp0__out_ff_2_t19 p0__out_ff_2_19 p0__out_ff_2_20 PTL_M3
Xp0__out_ff_2_t20 p0__out_ff_2_20 p0__out_ff_2_21 PTL_M3
Xp0__out_ff_2_t21 p0__out_ff_2_21 p0__out_ff_2_22 PTL_M3
Xp0__out_ff_2_t22 p0__out_ff_2_22 p0__out_ff_2_23 PTL_M3
Xp0__out_ff_2_t23 p0__out_ff_2_23 p0__out_ff_2_24 PTL_M3
Xp0__out_ff_2_t24 p0__out_ff_2_24 p0__out_ff_2_25 BEND_PTL_M3
Xp0__out_ff_2_t25 p0__out_ff_2_25 p0__out_ff_2_26 PTL_M3
Xp0__out_ff_2_t26 p0__out_ff_2_26 p0__out_ff_2_27 PTL_M3
Xp0__out_ff_2_t27 p0__out_ff_2_27 p0__out_ff_2_28 PTL_M3
Xp0__out_ff_2_t28 p0__out_ff_2_28 p0__out_ff_2_29 PTL_M3
Xp0__out_ff_2_t29 p0__out_ff_2_29 p0__out_ff_2_30 PTL_M3
Xp0__out_ff_2_t30 p0__out_ff_2_30 p0__out_ff_2_31 PTL_M3
Xp0__out_ff_2_t31 p0__out_ff_2_31 p0__out_ff_2_32 PTL_M3
Xp0__out_ff_2_t32 p0__out_ff_2_32 p0__out_ff_2_33 PTL_M3
Xp0__out_ff_2_t33 p0__out_ff_2_33 p0__out_ff_2_34 PTL_M3
Xp0__out_ff_2_t34 p0__out_ff_2_34 p0__out_ff_2_35 PTL_M3
Xp0__out_ff_2_t35 p0__out_ff_2_35 p0__out_ff_2_36 BEND_PTL_M3
Xp0__out_ff_2_t36 p0__out_ff_2_36 p0__out_ff_2_37 PTL_M3
Xp0__out_ff_2_t37 p0__out_ff_2_37 p0__out_ff_2_38 PTL_M3
Xp0__out_ff_2_t38 p0__out_ff_2_38 p0__out_ff_2_39 PTL_M3
Xp0__out_ff_2_t39 p0__out_ff_2_39 p0__out_ff_2_40 PTL_M3
Xp0__out_ff_2_t40 p0__out_ff_2_40 p0__out_ff_2_41 PTL_M3
Xp0__out_ff_2_t41 p0__out_ff_2_41 p0__out_ff_2_42 PTL_M3
Xp0__out_ff_2_t42 p0__out_ff_2_42 p0__out_ff_2_43 BEND_PTL_M3
Xp0__out_ff_2_t43 p0__out_ff_2_43 p0__out_ff_2_44 PTL_M3
Xp0__out_ff_2_t44 p0__out_ff_2_44 p0__out_ff_2_45 PTL_M3
Xp0__out_ff_2_t45 p0__out_ff_2_45 p0__out_ff_2_46 PTL_M3
Xp0__out_ff_2_t46 p0__out_ff_2_46 p0__out_ff_2_47 PTL_M3
Xp0__out_ff_2_t47 p0__out_ff_2_47 p0__out_ff_2_48 BEND_PTL_M3
Xp0__out_ff_2_t48 p0__out_ff_2_48 p0__out_ff_2_o PTLCAP_M3
Xclk_row_1__spl_3_t0 clk_row_1__spl_3_i clk_row_1__spl_3_1 PTLCAP_M3
Xclk_row_1__spl_3_t1 clk_row_1__spl_3_1 clk_row_1__spl_3_2 PTL_M3
Xclk_row_1__spl_3_t2 clk_row_1__spl_3_2 clk_row_1__spl_3_3 BEND_PTL_M3
Xclk_row_1__spl_3_t3 clk_row_1__spl_3_3 clk_row_1__spl_3_4 PTL_M3
Xclk_row_1__spl_3_t4 clk_row_1__spl_3_4 clk_row_1__spl_3_5 PTL_M3
Xclk_row_1__spl_3_t5 clk_row_1__spl_3_5 clk_row_1__spl_3_6 PTL_M3
Xclk_row_1__spl_3_t6 clk_row_1__spl_3_6 clk_row_1__spl_3_7 VIA_M1_M3_BENDN
Xclk_row_1__spl_3_t7 clk_row_1__spl_3_7 clk_row_1__spl_3_8 PTL_M1
Xclk_row_1__spl_3_t8 clk_row_1__spl_3_8 clk_row_1__spl_3_9 PTL_M1
Xclk_row_1__spl_3_t9 clk_row_1__spl_3_9 clk_row_1__spl_3_10 PTL_M1
Xclk_row_1__spl_3_t10 clk_row_1__spl_3_10 clk_row_1__spl_3_11 VIA_M1_M3_STRAIGHT
Xclk_row_1__spl_3_t11 clk_row_1__spl_3_11 clk_row_1__spl_3_12 PTL_M3
Xclk_row_1__spl_3_t12 clk_row_1__spl_3_12 clk_row_1__spl_3_13 PTL_M3
Xclk_row_1__spl_3_t13 clk_row_1__spl_3_13 clk_row_1__spl_3_14 PTL_M3
Xclk_row_1__spl_3_t14 clk_row_1__spl_3_14 clk_row_1__spl_3_15 PTL_M3
Xclk_row_1__spl_3_t15 clk_row_1__spl_3_15 clk_row_1__spl_3_16 PTL_M3
Xclk_row_1__spl_3_t16 clk_row_1__spl_3_16 clk_row_1__spl_3_17 PTL_M3
Xclk_row_1__spl_3_t17 clk_row_1__spl_3_17 clk_row_1__spl_3_18 PTL_M3
Xclk_row_1__spl_3_t18 clk_row_1__spl_3_18 clk_row_1__spl_3_19 PTL_M3
Xclk_row_1__spl_3_t19 clk_row_1__spl_3_19 clk_row_1__spl_3_20 PTL_M3
Xclk_row_1__spl_3_t20 clk_row_1__spl_3_20 clk_row_1__spl_3_21 PTL_M3
Xclk_row_1__spl_3_t21 clk_row_1__spl_3_21 clk_row_1__spl_3_22 PTL_M3
Xclk_row_1__spl_3_t22 clk_row_1__spl_3_22 clk_row_1__spl_3_23 PTL_M3
Xclk_row_1__spl_3_t23 clk_row_1__spl_3_23 clk_row_1__spl_3_24 PTL_M3
Xclk_row_1__spl_3_t24 clk_row_1__spl_3_24 clk_row_1__spl_3_25 BEND_PTL_M3
Xclk_row_1__spl_3_t25 clk_row_1__spl_3_25 clk_row_1__spl_3_26 PTL_M3
Xclk_row_1__spl_3_t26 clk_row_1__spl_3_26 clk_row_1__spl_3_27 PTL_M3
Xclk_row_1__spl_3_t27 clk_row_1__spl_3_27 clk_row_1__spl_3_28 PTL_M3
Xclk_row_1__spl_3_t28 clk_row_1__spl_3_28 clk_row_1__spl_3_29 PTL_M3
Xclk_row_1__spl_3_t29 clk_row_1__spl_3_29 clk_row_1__spl_3_30 PTL_M3
Xclk_row_1__spl_3_t30 clk_row_1__spl_3_30 clk_row_1__spl_3_31 PTL_M3
Xclk_row_1__spl_3_t31 clk_row_1__spl_3_31 clk_row_1__spl_3_32 PTL_M3
Xclk_row_1__spl_3_t32 clk_row_1__spl_3_32 clk_row_1__spl_3_33 PTL_M3
Xclk_row_1__spl_3_t33 clk_row_1__spl_3_33 clk_row_1__spl_3_34 PTL_M3
Xclk_row_1__spl_3_t34 clk_row_1__spl_3_34 clk_row_1__spl_3_35 PTL_M3
Xclk_row_1__spl_3_t35 clk_row_1__spl_3_35 clk_row_1__spl_3_36 PTL_M3
Xclk_row_1__spl_3_t36 clk_row_1__spl_3_36 clk_row_1__spl_3_o PTLCAP_M3
XTHmitll_AND2T_1 a0__spl_11_o b0__spl_5_o clk_row_1__spl_6_o n1_i THmitll_AND2T
XTHmitll_AND2T_2 a0__spl_12_o b1__spl_1_o clk_row_1__spl_5_o n2_i THmitll_AND2T
XTHmitll_AND2T_3 a1__spl_15_o b0__spl_6_o clk_row_1__spl_3_o n3_i THmitll_AND2T
XTHmitll_AND2T_4 a1__spl_16_o b1__spl_2_o clk_row_1__spl_2_o n4_i THmitll_AND2T
XTHmitll_XORT_5 n2__spl_13_o n3__spl_9_o clk_row_2__spl_6_o n5_i THmitll_XORT
XTHmitll_AND2T_6 n2__spl_14_o n3__spl_10_o clk_row_2__spl_5_o n6_i THmitll_AND2T
XTHmitll_AND2T_7 n4__spl_7__ff_2_o n6__spl_3_o clk_row_3__spl_6_o n8_i THmitll_AND2T
XTHmitll_JTLT_8 n1_o p0__out_entry_1_i THmitll_JTLT
XTHmitll_JTLT_9 n5_o p1__out_entry_4_i THmitll_JTLT
XTHmitll_XORT_10 n4__spl_8__ff_1_o n6__spl_4_o clk_row_3__spl_5_o p2_i THmitll_XORT
XTHmitll_JTLT_11 n8_o p3_i THmitll_JTLT
XTHmitll_SPLITT_12 b1_o b1__spl_2_i b1__spl_1_i THmitll_SPLITT
XTHmitll_SPLITT_13 n6_o n6__spl_4_i n6__spl_3_i THmitll_SPLITT
XTHmitll_SPLITT_14 b0_o b0__spl_6_i b0__spl_5_i THmitll_SPLITT
XTHmitll_SPLITT_15 n4__ff_1_o n4__spl_8__ff_1_i n4__spl_7__ff_2_i THmitll_SPLITT
XTHmitll_SPLITT_16 n3_o n3__spl_10_i n3__spl_9_i THmitll_SPLITT
XTHmitll_SPLITT_17 a0_o a0__spl_12_i a0__spl_11_i THmitll_SPLITT
XTHmitll_SPLITT_18 n2_o n2__spl_14_i n2__spl_13_i THmitll_SPLITT
XTHmitll_SPLITT_19 a1_o a1__spl_16_i a1__spl_15_i THmitll_SPLITT
XTHmitll_DFFT_20 n4_o clk_row_2__spl_3_o n4__ff_1_i THmitll_DFFT
XTHmitll_DFFT_21 p0__out_entry_1_o clk_row_2__spl_2_o p0__out_ff_2_i THmitll_DFFT
XTHmitll_DFFT_22 p0__out_ff_2_o clk_row_3__spl_3_o p0_i THmitll_DFFT
XTHmitll_DFFT_23 p1__out_entry_4_o clk_row_3__spl_2_o p1_i THmitll_DFFT
XTHmitll_SPLITT_1_0 clk_row_1_o clk_row_1__spl_4_i clk_row_1__spl_1_i THmitll_SPLITT
XTHmitll_SPLITT_1_1 clk_row_1__spl_1_o clk_row_1__spl_3_i clk_row_1__spl_2_i THmitll_SPLITT
XTHmitll_SPLITT_1_4 clk_row_1__spl_4_o clk_row_1__spl_6_i clk_row_1__spl_5_i THmitll_SPLITT
XTHmitll_SPLITT_2_0 clk_row_2_o clk_row_2__spl_4_i clk_row_2__spl_1_i THmitll_SPLITT
XTHmitll_SPLITT_2_1 clk_row_2__spl_1_o clk_row_2__spl_3_i clk_row_2__spl_2_i THmitll_SPLITT
XTHmitll_SPLITT_2_4 clk_row_2__spl_4_o clk_row_2__spl_6_i clk_row_2__spl_5_i THmitll_SPLITT
XTHmitll_SPLITT_3_0 clk_row_3_o clk_row_3__spl_4_i clk_row_3__spl_1_i THmitll_SPLITT
XTHmitll_SPLITT_3_1 clk_row_3__spl_1_o clk_row_3__spl_3_i clk_row_3__spl_2_i THmitll_SPLITT
XTHmitll_SPLITT_3_4 clk_row_3__spl_4_o clk_row_3__spl_6_i clk_row_3__spl_5_i THmitll_SPLITT
XTHmitll_SPLITT_sp0 clk_o clk_spine_1_i clk_row_3_i THmitll_SPLITT
XTHmitll_SPLITT_sp1 clk_spine_1_o clk_row_1_i clk_row_2_i THmitll_SPLITT
