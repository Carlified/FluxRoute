* mult_2x2_tb.cir - generated by make_tb.py
* clock period 100 ps, 16 slots
* clock launch 50 ps, data launch 131.45 ps (data-clock 81.45 ps)
* input window 35.7 .. 127.2 ps relative to clock send

.include mult_2x2.cir
.include lib/THmitll_DCSFQ-PTLTX_v3p0_extracted.cir
.include lib/THmitll_PTLRX-SFQDC_v3p0_extracted.cir

* ===== clock =====
I_clk 0 nclk pulse(0 600u 50p 2p 2p 3p 100p)
XSCLK THmitll_DCSFQ-PTLTX nclk clk_i

* ===== data inputs =====
* a0 = 0000000011111111
I_a0 0 na0 PWL(0 0 931.45p 0 934.45p 600u 937.45p 0 1031.45p 0 1034.45p 600u 1037.45p 0 1131.45p 0 1134.45p 600u 1137.45p 0 1231.45p 0 1234.45p 600u 1237.45p 0 1331.45p 0 1334.45p 600u 1337.45p 0 1431.45p 0 1434.45p 600u 1437.45p 0 1531.45p 0 1534.45p 600u 1537.45p 0 1631.45p 0 1634.45p 600u 1637.45p 0)
XSa0 THmitll_DCSFQ-PTLTX na0 a0_i
* a1 = 0000111100001111
I_a1 0 na1 PWL(0 0 531.45p 0 534.45p 600u 537.45p 0 631.45p 0 634.45p 600u 637.45p 0 731.45p 0 734.45p 600u 737.45p 0 831.45p 0 834.45p 600u 837.45p 0 1331.45p 0 1334.45p 600u 1337.45p 0 1431.45p 0 1434.45p 600u 1437.45p 0 1531.45p 0 1534.45p 600u 1537.45p 0 1631.45p 0 1634.45p 600u 1637.45p 0)
XSa1 THmitll_DCSFQ-PTLTX na1 a1_i
* b0 = 0011001100110011
I_b0 0 nb0 PWL(0 0 331.45p 0 334.45p 600u 337.45p 0 431.45p 0 434.45p 600u 437.45p 0 731.45p 0 734.45p 600u 737.45p 0 831.45p 0 834.45p 600u 837.45p 0 1131.45p 0 1134.45p 600u 1137.45p 0 1231.45p 0 1234.45p 600u 1237.45p 0 1531.45p 0 1534.45p 600u 1537.45p 0 1631.45p 0 1634.45p 600u 1637.45p 0)
XSb0 THmitll_DCSFQ-PTLTX nb0 b0_i
* b1 = 0101010101010101
I_b1 0 nb1 PWL(0 0 231.45p 0 234.45p 600u 237.45p 0 431.45p 0 434.45p 600u 437.45p 0 631.45p 0 634.45p 600u 637.45p 0 831.45p 0 834.45p 600u 837.45p 0 1031.45p 0 1034.45p 600u 1037.45p 0 1231.45p 0 1234.45p 600u 1237.45p 0 1431.45p 0 1434.45p 600u 1437.45p 0 1631.45p 0 1634.45p 600u 1637.45p 0)
XSb1 THmitll_DCSFQ-PTLTX nb1 b1_i

* ===== readout =====
XRp0 THmitll_PTLRX-SFQDC p0_o rp0
Rp0 rp0 0 2
XRp1 THmitll_PTLRX-SFQDC p1_o rp1
Rp1 rp1 0 2
XRp2 THmitll_PTLRX-SFQDC p2_o rp2
Rp2 rp2 0 2
XRp3 THmitll_PTLRX-SFQDC p3_o rp3
Rp3 rp3 0 2

* ===== analysis =====
* output watch 289.9 ps, decode window 389.9 ps (max depth 3, periods 2, travel 39.9 ps)
.tran 0.05p 1989.9p 0
.print p(B3.XSCLK) v(clk_i) i(I_clk) i(I_a0) i(I_a1) i(I_b0) i(I_b1) v(a0_i) v(a1_i) v(b0_i) v(b1_i) p(B1.XRp0) p(B1.XRp1) p(B1.XRp2) p(B1.XRp3) v(rp0) v(rp1) v(rp2) v(rp3)
.end
