* --- subcircuit includes ---
.include lib/PTL_M3.cir
.include lib/PTLCAP_M1.cir
.include lib/PTL_M1.cir
.include lib/VIA_M1_M3_STRAIGHT.cir
.include lib/BEND_PTL_M1.cir
.include lib/PTLCAP_M3.cir
.include lib/VIA_M1_M3_BENDS.cir
.include lib/BEND_PTL_M3.cir
.include lib/SPLIT_M5_3.cir
.include lib/SPLIT_M5_3_S.cir
.include lib/SPLIT_M5_3_WE.cir
.include lib/SPLIT_M5_4_SN.cir
.include lib/VIA_M1_M3_BENDN.cir
.include lib/THmitll_XORT_v3p0_extracted.cir
.include lib/THmitll_AND2T_v3p0_extracted.cir
.include lib/THmitll_OR2T_v3p0_extracted.cir
.include lib/THmitll_SPLITT_v3p0_extracted.cir
.include lib/THmitll_DFFT_v3p0_extracted.cir
.include lib/THmitll_BUFFT_v3p0_extracted.cir
.include lib/THmitll_JTLT_v3p0_extracted.cir

* rca2 - SPICE netlist (flat)

* clock map: model=30 clock=58 clknet=21 clksig=21
Xx1__ff_2__ff_3_t0 x1__ff_2__ff_3_i x1__ff_2__ff_3_1 PTLCAP_M1
Xx1__ff_2__ff_3_t1 x1__ff_2__ff_3_1 x1__ff_2__ff_3_2 BEND_PTL_M1
Xx1__ff_2__ff_3_t2 x1__ff_2__ff_3_2 x1__ff_2__ff_3_3 PTL_M1
Xx1__ff_2__ff_3_t3 x1__ff_2__ff_3_3 x1__ff_2__ff_3_4 PTL_M1
Xx1__ff_2__ff_3_t4 x1__ff_2__ff_3_4 x1__ff_2__ff_3_5 PTL_M1
Xx1__ff_2__ff_3_t5 x1__ff_2__ff_3_5 x1__ff_2__ff_3_6 PTL_M1
Xx1__ff_2__ff_3_t6 x1__ff_2__ff_3_6 x1__ff_2__ff_3_7 PTL_M1
Xx1__ff_2__ff_3_t7 x1__ff_2__ff_3_7 x1__ff_2__ff_3_8 BEND_PTL_M1
Xx1__ff_2__ff_3_t8 x1__ff_2__ff_3_8 x1__ff_2__ff_3_o PTLCAP_M1
Xclk_row_4__spl_4_t0 clk_row_4__spl_4_i clk_row_4__spl_4_1 PTLCAP_M1
Xclk_row_4__spl_4_t1 clk_row_4__spl_4_1 clk_row_4__spl_4_2 PTL_M1
Xclk_row_4__spl_4_t2 clk_row_4__spl_4_2 clk_row_4__spl_4_3 PTL_M1
Xclk_row_4__spl_4_t3 clk_row_4__spl_4_3 clk_row_4__spl_4_4 PTL_M1
Xclk_row_4__spl_4_t4 clk_row_4__spl_4_4 clk_row_4__spl_4_5 BEND_PTL_M1
Xclk_row_4__spl_4_t5 clk_row_4__spl_4_5 clk_row_4__spl_4_6 PTL_M1
Xclk_row_4__spl_4_t6 clk_row_4__spl_4_6 clk_row_4__spl_4_o PTLCAP_M1
Xclk_row_1__spl_7_t0 clk_row_1__spl_7_i clk_row_1__spl_7_1 PTLCAP_M1
Xclk_row_1__spl_7_t1 clk_row_1__spl_7_1 clk_row_1__spl_7_2 PTL_M1
Xclk_row_1__spl_7_t2 clk_row_1__spl_7_2 clk_row_1__spl_7_3 PTL_M1
Xclk_row_1__spl_7_t3 clk_row_1__spl_7_3 clk_row_1__spl_7_4 BEND_PTL_M1
Xclk_row_1__spl_7_t4 clk_row_1__spl_7_4 clk_row_1__spl_7_5 PTL_M1
Xclk_row_1__spl_7_t5 clk_row_1__spl_7_5 clk_row_1__spl_7_6 PTL_M1
Xclk_row_1__spl_7_t6 clk_row_1__spl_7_6 clk_row_1__spl_7_o PTLCAP_M1
Xclk_row_1__spl_8_t0 clk_row_1__spl_8_i clk_row_1__spl_8_1 PTLCAP_M1
Xclk_row_1__spl_8_t1 clk_row_1__spl_8_1 clk_row_1__spl_8_2 PTL_M1
Xclk_row_1__spl_8_t2 clk_row_1__spl_8_2 clk_row_1__spl_8_3 PTL_M1
Xclk_row_1__spl_8_t3 clk_row_1__spl_8_3 clk_row_1__spl_8_4 PTL_M1
Xclk_row_1__spl_8_t4 clk_row_1__spl_8_4 clk_row_1__spl_8_5 BEND_PTL_M1
Xclk_row_1__spl_8_t5 clk_row_1__spl_8_5 clk_row_1__spl_8_6 PTL_M1
Xclk_row_1__spl_8_t6 clk_row_1__spl_8_6 clk_row_1__spl_8_o PTLCAP_M1
Xclk_row_2__spl_8_t0 clk_row_2__spl_8_i clk_row_2__spl_8_1 PTLCAP_M1
Xclk_row_2__spl_8_t1 clk_row_2__spl_8_1 clk_row_2__spl_8_2 PTL_M1
Xclk_row_2__spl_8_t2 clk_row_2__spl_8_2 clk_row_2__spl_8_3 PTL_M1
Xclk_row_2__spl_8_t3 clk_row_2__spl_8_3 clk_row_2__spl_8_4 PTL_M1
Xclk_row_2__spl_8_t4 clk_row_2__spl_8_4 clk_row_2__spl_8_5 BEND_PTL_M1
Xclk_row_2__spl_8_t5 clk_row_2__spl_8_5 clk_row_2__spl_8_6 PTL_M1
Xclk_row_2__spl_8_t6 clk_row_2__spl_8_6 clk_row_2__spl_8_o PTLCAP_M1
Xclk_row_2__spl_7_t0 clk_row_2__spl_7_i clk_row_2__spl_7_1 PTLCAP_M1
Xclk_row_2__spl_7_t1 clk_row_2__spl_7_1 clk_row_2__spl_7_2 PTL_M1
Xclk_row_2__spl_7_t2 clk_row_2__spl_7_2 clk_row_2__spl_7_3 PTL_M1
Xclk_row_2__spl_7_t3 clk_row_2__spl_7_3 clk_row_2__spl_7_4 BEND_PTL_M1
Xclk_row_2__spl_7_t4 clk_row_2__spl_7_4 clk_row_2__spl_7_5 PTL_M1
Xclk_row_2__spl_7_t5 clk_row_2__spl_7_5 clk_row_2__spl_7_6 PTL_M1
Xclk_row_2__spl_7_t6 clk_row_2__spl_7_6 clk_row_2__spl_7_o PTLCAP_M1
Xclk_row_1__spl_2_t0 clk_row_1__spl_2_i clk_row_1__spl_2_1 PTLCAP_M1
Xclk_row_1__spl_2_t1 clk_row_1__spl_2_1 clk_row_1__spl_2_2 PTL_M1
Xclk_row_1__spl_2_t2 clk_row_1__spl_2_2 clk_row_1__spl_2_3 BEND_PTL_M1
Xclk_row_1__spl_2_t3 clk_row_1__spl_2_3 clk_row_1__spl_2_4 PTL_M1
Xclk_row_1__spl_2_t4 clk_row_1__spl_2_4 clk_row_1__spl_2_5 PTL_M1
Xclk_row_1__spl_2_t5 clk_row_1__spl_2_5 clk_row_1__spl_2_6 PTL_M1
Xclk_row_1__spl_2_t6 clk_row_1__spl_2_6 clk_row_1__spl_2_7 PTL_M1
Xclk_row_1__spl_2_t7 clk_row_1__spl_2_7 clk_row_1__spl_2_o PTLCAP_M1
Xclk_row_3__spl_4_t0 clk_row_3__spl_4_i clk_row_3__spl_4_1 PTLCAP_M1
Xclk_row_3__spl_4_t1 clk_row_3__spl_4_1 clk_row_3__spl_4_2 PTL_M1
Xclk_row_3__spl_4_t2 clk_row_3__spl_4_2 clk_row_3__spl_4_3 PTL_M1
Xclk_row_3__spl_4_t3 clk_row_3__spl_4_3 clk_row_3__spl_4_4 PTL_M1
Xclk_row_3__spl_4_t4 clk_row_3__spl_4_4 clk_row_3__spl_4_5 BEND_PTL_M1
Xclk_row_3__spl_4_t5 clk_row_3__spl_4_5 clk_row_3__spl_4_6 PTL_M1
Xclk_row_3__spl_4_t6 clk_row_3__spl_4_6 clk_row_3__spl_4_7 PTL_M1
Xclk_row_3__spl_4_t7 clk_row_3__spl_4_7 clk_row_3__spl_4_8 PTL_M1
Xclk_row_3__spl_4_t8 clk_row_3__spl_4_8 clk_row_3__spl_4_o PTLCAP_M1
Xclk_row_1__spl_5_t0 clk_row_1__spl_5_i clk_row_1__spl_5_1 PTLCAP_M1
Xclk_row_1__spl_5_t1 clk_row_1__spl_5_1 clk_row_1__spl_5_2 PTL_M1
Xclk_row_1__spl_5_t2 clk_row_1__spl_5_2 clk_row_1__spl_5_3 PTL_M1
Xclk_row_1__spl_5_t3 clk_row_1__spl_5_3 clk_row_1__spl_5_4 PTL_M1
Xclk_row_1__spl_5_t4 clk_row_1__spl_5_4 clk_row_1__spl_5_5 PTL_M1
Xclk_row_1__spl_5_t5 clk_row_1__spl_5_5 clk_row_1__spl_5_6 BEND_PTL_M1
Xclk_row_1__spl_5_t6 clk_row_1__spl_5_6 clk_row_1__spl_5_7 PTL_M1
Xclk_row_1__spl_5_t7 clk_row_1__spl_5_7 clk_row_1__spl_5_8 PTL_M1
Xclk_row_1__spl_5_t8 clk_row_1__spl_5_8 clk_row_1__spl_5_9 PTL_M1
Xclk_row_1__spl_5_t9 clk_row_1__spl_5_9 clk_row_1__spl_5_10 PTL_M1
Xclk_row_1__spl_5_t10 clk_row_1__spl_5_10 clk_row_1__spl_5_11 PTL_M1
Xclk_row_1__spl_5_t11 clk_row_1__spl_5_11 clk_row_1__spl_5_12 PTL_M1
Xclk_row_1__spl_5_t12 clk_row_1__spl_5_12 clk_row_1__spl_5_13 BEND_PTL_M1
Xclk_row_1__spl_5_t13 clk_row_1__spl_5_13 clk_row_1__spl_5_14 PTL_M1
Xclk_row_1__spl_5_t14 clk_row_1__spl_5_14 clk_row_1__spl_5_15 PTL_M1
Xclk_row_1__spl_5_t15 clk_row_1__spl_5_15 clk_row_1__spl_5_o PTLCAP_M1
Xclk_row_1__spl_4_t0 clk_row_1__spl_4_i clk_row_1__spl_4_1 PTLCAP_M1
Xclk_row_1__spl_4_t1 clk_row_1__spl_4_1 clk_row_1__spl_4_2 PTL_M1
Xclk_row_1__spl_4_t2 clk_row_1__spl_4_2 clk_row_1__spl_4_3 PTL_M1
Xclk_row_1__spl_4_t3 clk_row_1__spl_4_3 clk_row_1__spl_4_4 PTL_M1
Xclk_row_1__spl_4_t4 clk_row_1__spl_4_4 clk_row_1__spl_4_5 BEND_PTL_M1
Xclk_row_1__spl_4_t5 clk_row_1__spl_4_5 clk_row_1__spl_4_6 PTL_M1
Xclk_row_1__spl_4_t6 clk_row_1__spl_4_6 clk_row_1__spl_4_7 PTL_M1
Xclk_row_1__spl_4_t7 clk_row_1__spl_4_7 clk_row_1__spl_4_8 PTL_M1
Xclk_row_1__spl_4_t8 clk_row_1__spl_4_8 clk_row_1__spl_4_9 PTL_M1
Xclk_row_1__spl_4_t9 clk_row_1__spl_4_9 clk_row_1__spl_4_10 PTL_M1
Xclk_row_1__spl_4_t10 clk_row_1__spl_4_10 clk_row_1__spl_4_11 PTL_M1
Xclk_row_1__spl_4_t11 clk_row_1__spl_4_11 clk_row_1__spl_4_12 PTL_M1
Xclk_row_1__spl_4_t12 clk_row_1__spl_4_12 clk_row_1__spl_4_13 BEND_PTL_M1
Xclk_row_1__spl_4_t13 clk_row_1__spl_4_13 clk_row_1__spl_4_14 PTL_M1
Xclk_row_1__spl_4_t14 clk_row_1__spl_4_14 clk_row_1__spl_4_15 PTL_M1
Xclk_row_1__spl_4_t15 clk_row_1__spl_4_15 clk_row_1__spl_4_16 PTL_M1
Xclk_row_1__spl_4_t16 clk_row_1__spl_4_16 clk_row_1__spl_4_17 BEND_PTL_M1
Xclk_row_1__spl_4_t17 clk_row_1__spl_4_17 clk_row_1__spl_4_18 PTL_M1
Xclk_row_1__spl_4_t18 clk_row_1__spl_4_18 clk_row_1__spl_4_o PTLCAP_M1
Xa0_t0 a0_i a0_1 PTLCAP_M1
Xa0_t1 a0_1 a0_2 PTL_M1
Xa0_t2 a0_2 a0_3 PTL_M1
Xa0_t3 a0_3 a0_4 PTL_M1
Xa0_t4 a0_4 a0_5 PTL_M1
Xa0_t5 a0_5 a0_6 PTL_M1
Xa0_t6 a0_6 a0_7 PTL_M1
Xa0_t7 a0_7 a0_8 PTL_M1
Xa0_t8 a0_8 a0_9 PTL_M1
Xa0_t9 a0_9 a0_10 BEND_PTL_M1
Xa0_t10 a0_10 a0_o PTLCAP_M1
Xclk_row_4__spl_1_t0 clk_row_4__spl_1_i clk_row_4__spl_1_1 PTLCAP_M1
Xclk_row_4__spl_1_t1 clk_row_4__spl_1_1 clk_row_4__spl_1_2 PTL_M1
Xclk_row_4__spl_1_t2 clk_row_4__spl_1_2 clk_row_4__spl_1_3 PTL_M1
Xclk_row_4__spl_1_t3 clk_row_4__spl_1_3 clk_row_4__spl_1_4 BEND_PTL_M1
Xclk_row_4__spl_1_t4 clk_row_4__spl_1_4 clk_row_4__spl_1_5 PTL_M1
Xclk_row_4__spl_1_t5 clk_row_4__spl_1_5 clk_row_4__spl_1_6 PTL_M1
Xclk_row_4__spl_1_t6 clk_row_4__spl_1_6 clk_row_4__spl_1_7 PTL_M1
Xclk_row_4__spl_1_t7 clk_row_4__spl_1_7 clk_row_4__spl_1_8 BEND_PTL_M1
Xclk_row_4__spl_1_t8 clk_row_4__spl_1_8 clk_row_4__spl_1_9 PTL_M1
Xclk_row_4__spl_1_t9 clk_row_4__spl_1_9 clk_row_4__spl_1_10 PTL_M1
Xclk_row_4__spl_1_t10 clk_row_4__spl_1_10 clk_row_4__spl_1_11 BEND_PTL_M1
Xclk_row_4__spl_1_t11 clk_row_4__spl_1_11 clk_row_4__spl_1_o PTLCAP_M1
Xclk_row_2__spl_5_t0 clk_row_2__spl_5_i clk_row_2__spl_5_1 PTLCAP_M1
Xclk_row_2__spl_5_t1 clk_row_2__spl_5_1 clk_row_2__spl_5_2 PTL_M1
Xclk_row_2__spl_5_t2 clk_row_2__spl_5_2 clk_row_2__spl_5_3 PTL_M1
Xclk_row_2__spl_5_t3 clk_row_2__spl_5_3 clk_row_2__spl_5_4 PTL_M1
Xclk_row_2__spl_5_t4 clk_row_2__spl_5_4 clk_row_2__spl_5_5 PTL_M1
Xclk_row_2__spl_5_t5 clk_row_2__spl_5_5 clk_row_2__spl_5_6 PTL_M1
Xclk_row_2__spl_5_t6 clk_row_2__spl_5_6 clk_row_2__spl_5_7 PTL_M1
Xclk_row_2__spl_5_t7 clk_row_2__spl_5_7 clk_row_2__spl_5_8 PTL_M1
Xclk_row_2__spl_5_t8 clk_row_2__spl_5_8 clk_row_2__spl_5_9 PTL_M1
Xclk_row_2__spl_5_t9 clk_row_2__spl_5_9 clk_row_2__spl_5_10 BEND_PTL_M1
Xclk_row_2__spl_5_t10 clk_row_2__spl_5_10 clk_row_2__spl_5_11 PTL_M1
Xclk_row_2__spl_5_t11 clk_row_2__spl_5_11 clk_row_2__spl_5_o PTLCAP_M1
Xc1_t0 c1_i c1_1 PTLCAP_M1
Xc1_t1 c1_1 c1_2 PTL_M1
Xc1_t2 c1_2 c1_3 PTL_M1
Xc1_t3 c1_3 c1_4 PTL_M1
Xc1_t4 c1_4 c1_5 PTL_M1
Xc1_t5 c1_5 c1_6 PTL_M1
Xc1_t6 c1_6 c1_7 BEND_PTL_M1
Xc1_t7 c1_7 c1_8 PTL_M1
Xc1_t8 c1_8 c1_9 PTL_M1
Xc1_t9 c1_9 c1_10 PTL_M1
Xc1_t10 c1_10 c1_11 PTL_M1
Xc1_t11 c1_11 c1_12 PTL_M1
Xc1_t12 c1_12 c1_o PTLCAP_M1
Xclk_row_3__spl_1_t0 clk_row_3__spl_1_i clk_row_3__spl_1_1 PTLCAP_M1
Xclk_row_3__spl_1_t1 clk_row_3__spl_1_1 clk_row_3__spl_1_2 PTL_M1
Xclk_row_3__spl_1_t2 clk_row_3__spl_1_2 clk_row_3__spl_1_3 PTL_M1
Xclk_row_3__spl_1_t3 clk_row_3__spl_1_3 clk_row_3__spl_1_4 PTL_M1
Xclk_row_3__spl_1_t4 clk_row_3__spl_1_4 clk_row_3__spl_1_5 PTL_M1
Xclk_row_3__spl_1_t5 clk_row_3__spl_1_5 clk_row_3__spl_1_6 BEND_PTL_M1
Xclk_row_3__spl_1_t6 clk_row_3__spl_1_6 clk_row_3__spl_1_7 PTL_M1
Xclk_row_3__spl_1_t7 clk_row_3__spl_1_7 clk_row_3__spl_1_8 PTL_M1
Xclk_row_3__spl_1_t8 clk_row_3__spl_1_8 clk_row_3__spl_1_9 PTL_M1
Xclk_row_3__spl_1_t9 clk_row_3__spl_1_9 clk_row_3__spl_1_10 BEND_PTL_M1
Xclk_row_3__spl_1_t10 clk_row_3__spl_1_10 clk_row_3__spl_1_11 PTL_M1
Xclk_row_3__spl_1_t11 clk_row_3__spl_1_11 clk_row_3__spl_1_12 PTL_M1
Xclk_row_3__spl_1_t12 clk_row_3__spl_1_12 clk_row_3__spl_1_13 BEND_PTL_M1
Xclk_row_3__spl_1_t13 clk_row_3__spl_1_13 clk_row_3__spl_1_o PTLCAP_M1
Xx0_t0 x0_i x0_1 PTLCAP_M1
Xx0_t1 x0_1 x0_2 PTL_M1
Xx0_t2 x0_2 x0_3 PTL_M1
Xx0_t3 x0_3 x0_4 PTL_M1
Xx0_t4 x0_4 x0_5 PTL_M1
Xx0_t5 x0_5 x0_6 BEND_PTL_M1
Xx0_t6 x0_6 x0_7 PTL_M1
Xx0_t7 x0_7 x0_8 PTL_M1
Xx0_t8 x0_8 x0_9 PTL_M1
Xx0_t9 x0_9 x0_10 PTL_M1
Xx0_t10 x0_10 x0_11 PTL_M1
Xx0_t11 x0_11 x0_12 PTL_M1
Xx0_t12 x0_12 x0_13 BEND_PTL_M1
Xx0_t13 x0_13 x0_o PTLCAP_M1
Xx1__ff_2__vbuf_1_t0 x1__ff_2__vbuf_1_i x1__ff_2__vbuf_1_1 PTLCAP_M1
Xx1__ff_2__vbuf_1_t1 x1__ff_2__vbuf_1_1 x1__ff_2__vbuf_1_2 PTL_M1
Xx1__ff_2__vbuf_1_t2 x1__ff_2__vbuf_1_2 x1__ff_2__vbuf_1_3 BEND_PTL_M1
Xx1__ff_2__vbuf_1_t3 x1__ff_2__vbuf_1_3 x1__ff_2__vbuf_1_4 PTL_M1
Xx1__ff_2__vbuf_1_t4 x1__ff_2__vbuf_1_4 x1__ff_2__vbuf_1_5 PTL_M1
Xx1__ff_2__vbuf_1_t5 x1__ff_2__vbuf_1_5 x1__ff_2__vbuf_1_6 PTL_M1
Xx1__ff_2__vbuf_1_t6 x1__ff_2__vbuf_1_6 x1__ff_2__vbuf_1_7 PTL_M1
Xx1__ff_2__vbuf_1_t7 x1__ff_2__vbuf_1_7 x1__ff_2__vbuf_1_8 PTL_M1
Xx1__ff_2__vbuf_1_t8 x1__ff_2__vbuf_1_8 x1__ff_2__vbuf_1_9 PTL_M1
Xx1__ff_2__vbuf_1_t9 x1__ff_2__vbuf_1_9 x1__ff_2__vbuf_1_10 PTL_M1
Xx1__ff_2__vbuf_1_t10 x1__ff_2__vbuf_1_10 x1__ff_2__vbuf_1_11 PTL_M1
Xx1__ff_2__vbuf_1_t11 x1__ff_2__vbuf_1_11 x1__ff_2__vbuf_1_12 PTL_M1
Xx1__ff_2__vbuf_1_t12 x1__ff_2__vbuf_1_12 x1__ff_2__vbuf_1_13 PTL_M1
Xx1__ff_2__vbuf_1_t13 x1__ff_2__vbuf_1_13 x1__ff_2__vbuf_1_14 BEND_PTL_M1
Xx1__ff_2__vbuf_1_t14 x1__ff_2__vbuf_1_14 x1__ff_2__vbuf_1_15 PTL_M1
Xx1__ff_2__vbuf_1_t15 x1__ff_2__vbuf_1_15 x1__ff_2__vbuf_1_16 PTL_M1
Xx1__ff_2__vbuf_1_t16 x1__ff_2__vbuf_1_16 x1__ff_2__vbuf_1_17 BEND_PTL_M1
Xx1__ff_2__vbuf_1_t17 x1__ff_2__vbuf_1_17 x1__ff_2__vbuf_1_o PTLCAP_M1
Xclk_row_4__spl_5_t0 clk_row_4__spl_5_i clk_row_4__spl_5_1 PTLCAP_M1
Xclk_row_4__spl_5_t1 clk_row_4__spl_5_1 clk_row_4__spl_5_2 BEND_PTL_M1
Xclk_row_4__spl_5_t2 clk_row_4__spl_5_2 clk_row_4__spl_5_3 PTL_M1
Xclk_row_4__spl_5_t3 clk_row_4__spl_5_3 clk_row_4__spl_5_4 PTL_M1
Xclk_row_4__spl_5_t4 clk_row_4__spl_5_4 clk_row_4__spl_5_5 PTL_M1
Xclk_row_4__spl_5_t5 clk_row_4__spl_5_5 clk_row_4__spl_5_6 PTL_M1
Xclk_row_4__spl_5_t6 clk_row_4__spl_5_6 clk_row_4__spl_5_7 PTL_M1
Xclk_row_4__spl_5_t7 clk_row_4__spl_5_7 clk_row_4__spl_5_8 PTL_M1
Xclk_row_4__spl_5_t8 clk_row_4__spl_5_8 clk_row_4__spl_5_9 BEND_PTL_M1
Xclk_row_4__spl_5_t9 clk_row_4__spl_5_9 clk_row_4__spl_5_10 PTL_M1
Xclk_row_4__spl_5_t10 clk_row_4__spl_5_10 clk_row_4__spl_5_11 PTL_M1
Xclk_row_4__spl_5_t11 clk_row_4__spl_5_11 clk_row_4__spl_5_12 PTL_M1
Xclk_row_4__spl_5_t12 clk_row_4__spl_5_12 clk_row_4__spl_5_13 PTL_M1
Xclk_row_4__spl_5_t13 clk_row_4__spl_5_13 clk_row_4__spl_5_14 BEND_PTL_M1
Xclk_row_4__spl_5_t14 clk_row_4__spl_5_14 clk_row_4__spl_5_15 PTL_M1
Xclk_row_4__spl_5_t15 clk_row_4__spl_5_15 clk_row_4__spl_5_o PTLCAP_M1
XTHmitll_DFFT__clkbuf_2_t0 THmitll_DFFT__clkbuf_2_i THmitll_DFFT__clkbuf_2_1 PTLCAP_M1
XTHmitll_DFFT__clkbuf_2_t1 THmitll_DFFT__clkbuf_2_1 THmitll_DFFT__clkbuf_2_2 BEND_PTL_M1
XTHmitll_DFFT__clkbuf_2_t2 THmitll_DFFT__clkbuf_2_2 THmitll_DFFT__clkbuf_2_3 PTL_M1
XTHmitll_DFFT__clkbuf_2_t3 THmitll_DFFT__clkbuf_2_3 THmitll_DFFT__clkbuf_2_4 PTL_M1
XTHmitll_DFFT__clkbuf_2_t4 THmitll_DFFT__clkbuf_2_4 THmitll_DFFT__clkbuf_2_5 PTL_M1
XTHmitll_DFFT__clkbuf_2_t5 THmitll_DFFT__clkbuf_2_5 THmitll_DFFT__clkbuf_2_6 PTL_M1
XTHmitll_DFFT__clkbuf_2_t6 THmitll_DFFT__clkbuf_2_6 THmitll_DFFT__clkbuf_2_7 PTL_M1
XTHmitll_DFFT__clkbuf_2_t7 THmitll_DFFT__clkbuf_2_7 THmitll_DFFT__clkbuf_2_8 PTL_M1
XTHmitll_DFFT__clkbuf_2_t8 THmitll_DFFT__clkbuf_2_8 THmitll_DFFT__clkbuf_2_9 PTL_M1
XTHmitll_DFFT__clkbuf_2_t9 THmitll_DFFT__clkbuf_2_9 THmitll_DFFT__clkbuf_2_10 PTL_M1
XTHmitll_DFFT__clkbuf_2_t10 THmitll_DFFT__clkbuf_2_10 THmitll_DFFT__clkbuf_2_11 PTL_M1
XTHmitll_DFFT__clkbuf_2_t11 THmitll_DFFT__clkbuf_2_11 THmitll_DFFT__clkbuf_2_12 PTL_M1
XTHmitll_DFFT__clkbuf_2_t12 THmitll_DFFT__clkbuf_2_12 THmitll_DFFT__clkbuf_2_13 PTL_M1
XTHmitll_DFFT__clkbuf_2_t13 THmitll_DFFT__clkbuf_2_13 THmitll_DFFT__clkbuf_2_o PTLCAP_M1
Xb1_t0 b1_i b1_1 PTLCAP_M1
Xb1_t1 b1_1 b1_2 PTL_M1
Xb1_t2 b1_2 b1_3 PTL_M1
Xb1_t3 b1_3 b1_4 PTL_M1
Xb1_t4 b1_4 b1_5 PTL_M1
Xb1_t5 b1_5 b1_6 PTL_M1
Xb1_t6 b1_6 b1_7 PTL_M1
Xb1_t7 b1_7 b1_8 PTL_M1
Xb1_t8 b1_8 b1_9 PTL_M1
Xb1_t9 b1_9 b1_10 BEND_PTL_M1
Xb1_t10 b1_10 b1_11 PTL_M1
Xb1_t11 b1_11 b1_12 PTL_M1
Xb1_t12 b1_12 b1_13 PTL_M1
Xb1_t13 b1_13 b1_14 PTL_M1
Xb1_t14 b1_14 b1_o PTLCAP_M1
Xclk_row_5__spl_4_t0 clk_row_5__spl_4_i clk_row_5__spl_4_1 PTLCAP_M1
Xclk_row_5__spl_4_t1 clk_row_5__spl_4_1 clk_row_5__spl_4_2 PTL_M1
Xclk_row_5__spl_4_t2 clk_row_5__spl_4_2 clk_row_5__spl_4_3 PTL_M1
Xclk_row_5__spl_4_t3 clk_row_5__spl_4_3 clk_row_5__spl_4_4 PTL_M1
Xclk_row_5__spl_4_t4 clk_row_5__spl_4_4 clk_row_5__spl_4_5 PTL_M1
Xclk_row_5__spl_4_t5 clk_row_5__spl_4_5 clk_row_5__spl_4_6 PTL_M1
Xclk_row_5__spl_4_t6 clk_row_5__spl_4_6 clk_row_5__spl_4_7 PTL_M1
Xclk_row_5__spl_4_t7 clk_row_5__spl_4_7 clk_row_5__spl_4_8 PTL_M1
Xclk_row_5__spl_4_t8 clk_row_5__spl_4_8 clk_row_5__spl_4_9 PTL_M1
Xclk_row_5__spl_4_t9 clk_row_5__spl_4_9 clk_row_5__spl_4_10 PTL_M1
Xclk_row_5__spl_4_t10 clk_row_5__spl_4_10 clk_row_5__spl_4_11 PTL_M1
Xclk_row_5__spl_4_t11 clk_row_5__spl_4_11 clk_row_5__spl_4_12 PTL_M1
Xclk_row_5__spl_4_t12 clk_row_5__spl_4_12 clk_row_5__spl_4_13 BEND_PTL_M1
Xclk_row_5__spl_4_t13 clk_row_5__spl_4_13 clk_row_5__spl_4_14 PTL_M1
Xclk_row_5__spl_4_t14 clk_row_5__spl_4_14 clk_row_5__spl_4_o PTLCAP_M1
Xclk_t0 clk_i clk_1 PTLCAP_M1
Xclk_t1 clk_1 clk_2 PTL_M1
Xclk_t2 clk_2 clk_3 PTL_M1
Xclk_t3 clk_3 clk_4 PTL_M1
Xclk_t4 clk_4 clk_5 PTL_M1
Xclk_t5 clk_5 clk_6 PTL_M1
Xclk_t6 clk_6 clk_7 PTL_M1
Xclk_t7 clk_7 clk_8 PTL_M1
Xclk_t8 clk_8 clk_9 PTL_M1
Xclk_t9 clk_9 clk_10 PTL_M1
Xclk_t10 clk_10 clk_11 PTL_M1
Xclk_t11 clk_11 clk_12 BEND_PTL_M1
Xclk_t12 clk_12 clk_13 PTL_M1
Xclk_t13 clk_13 clk_14 PTL_M1
Xclk_t14 clk_14 clk_o PTLCAP_M1
Xb1__spl_15_t0 b1__spl_15_i b1__spl_15_1 PTLCAP_M1
Xb1__spl_15_t1 b1__spl_15_1 b1__spl_15_2 BEND_PTL_M1
Xb1__spl_15_t2 b1__spl_15_2 b1__spl_15_3 PTL_M1
Xb1__spl_15_t3 b1__spl_15_3 b1__spl_15_4 PTL_M1
Xb1__spl_15_t4 b1__spl_15_4 b1__spl_15_5 PTL_M1
Xb1__spl_15_t5 b1__spl_15_5 b1__spl_15_6 PTL_M1
Xb1__spl_15_t6 b1__spl_15_6 b1__spl_15_7 PTL_M1
Xb1__spl_15_t7 b1__spl_15_7 b1__spl_15_8 PTL_M1
Xb1__spl_15_t8 b1__spl_15_8 b1__spl_15_9 PTL_M1
Xb1__spl_15_t9 b1__spl_15_9 b1__spl_15_10 PTL_M1
Xb1__spl_15_t10 b1__spl_15_10 b1__spl_15_11 PTL_M1
Xb1__spl_15_t11 b1__spl_15_11 b1__spl_15_12 PTL_M1
Xb1__spl_15_t12 b1__spl_15_12 b1__spl_15_13 PTL_M1
Xb1__spl_15_t13 b1__spl_15_13 b1__spl_15_14 PTL_M1
Xb1__spl_15_t14 b1__spl_15_14 b1__spl_15_15 PTL_M1
Xb1__spl_15_t15 b1__spl_15_15 b1__spl_15_16 BEND_PTL_M1
Xb1__spl_15_t16 b1__spl_15_16 b1__spl_15_o PTLCAP_M1
XTHmitll_XORT__clkbuf_7_t0 THmitll_XORT__clkbuf_7_i THmitll_XORT__clkbuf_7_1 PTLCAP_M1
XTHmitll_XORT__clkbuf_7_t1 THmitll_XORT__clkbuf_7_1 THmitll_XORT__clkbuf_7_2 BEND_PTL_M1
XTHmitll_XORT__clkbuf_7_t2 THmitll_XORT__clkbuf_7_2 THmitll_XORT__clkbuf_7_3 PTL_M1
XTHmitll_XORT__clkbuf_7_t3 THmitll_XORT__clkbuf_7_3 THmitll_XORT__clkbuf_7_4 PTL_M1
XTHmitll_XORT__clkbuf_7_t4 THmitll_XORT__clkbuf_7_4 THmitll_XORT__clkbuf_7_5 BEND_PTL_M1
XTHmitll_XORT__clkbuf_7_t5 THmitll_XORT__clkbuf_7_5 THmitll_XORT__clkbuf_7_6 PTL_M1
XTHmitll_XORT__clkbuf_7_t6 THmitll_XORT__clkbuf_7_6 THmitll_XORT__clkbuf_7_7 PTL_M1
XTHmitll_XORT__clkbuf_7_t7 THmitll_XORT__clkbuf_7_7 THmitll_XORT__clkbuf_7_8 PTL_M1
XTHmitll_XORT__clkbuf_7_t8 THmitll_XORT__clkbuf_7_8 THmitll_XORT__clkbuf_7_9 PTL_M1
XTHmitll_XORT__clkbuf_7_t9 THmitll_XORT__clkbuf_7_9 THmitll_XORT__clkbuf_7_10 PTL_M1
XTHmitll_XORT__clkbuf_7_t10 THmitll_XORT__clkbuf_7_10 THmitll_XORT__clkbuf_7_11 PTL_M1
XTHmitll_XORT__clkbuf_7_t11 THmitll_XORT__clkbuf_7_11 THmitll_XORT__clkbuf_7_12 PTL_M1
XTHmitll_XORT__clkbuf_7_t12 THmitll_XORT__clkbuf_7_12 THmitll_XORT__clkbuf_7_13 PTL_M1
XTHmitll_XORT__clkbuf_7_t13 THmitll_XORT__clkbuf_7_13 THmitll_XORT__clkbuf_7_14 PTL_M1
XTHmitll_XORT__clkbuf_7_t14 THmitll_XORT__clkbuf_7_14 THmitll_XORT__clkbuf_7_15 PTL_M1
XTHmitll_XORT__clkbuf_7_t15 THmitll_XORT__clkbuf_7_15 THmitll_XORT__clkbuf_7_o PTLCAP_M1
XTHmitll_XORT__clkbuf_4_t0 THmitll_XORT__clkbuf_4_i THmitll_XORT__clkbuf_4_1 PTLCAP_M1
XTHmitll_XORT__clkbuf_4_t1 THmitll_XORT__clkbuf_4_1 THmitll_XORT__clkbuf_4_2 BEND_PTL_M1
XTHmitll_XORT__clkbuf_4_t2 THmitll_XORT__clkbuf_4_2 THmitll_XORT__clkbuf_4_3 PTL_M1
XTHmitll_XORT__clkbuf_4_t3 THmitll_XORT__clkbuf_4_3 THmitll_XORT__clkbuf_4_4 PTL_M1
XTHmitll_XORT__clkbuf_4_t4 THmitll_XORT__clkbuf_4_4 THmitll_XORT__clkbuf_4_5 BEND_PTL_M1
XTHmitll_XORT__clkbuf_4_t5 THmitll_XORT__clkbuf_4_5 THmitll_XORT__clkbuf_4_6 PTL_M1
XTHmitll_XORT__clkbuf_4_t6 THmitll_XORT__clkbuf_4_6 THmitll_XORT__clkbuf_4_7 PTL_M1
XTHmitll_XORT__clkbuf_4_t7 THmitll_XORT__clkbuf_4_7 THmitll_XORT__clkbuf_4_8 PTL_M1
XTHmitll_XORT__clkbuf_4_t8 THmitll_XORT__clkbuf_4_8 THmitll_XORT__clkbuf_4_9 PTL_M1
XTHmitll_XORT__clkbuf_4_t9 THmitll_XORT__clkbuf_4_9 THmitll_XORT__clkbuf_4_10 PTL_M1
XTHmitll_XORT__clkbuf_4_t10 THmitll_XORT__clkbuf_4_10 THmitll_XORT__clkbuf_4_11 PTL_M1
XTHmitll_XORT__clkbuf_4_t11 THmitll_XORT__clkbuf_4_11 THmitll_XORT__clkbuf_4_12 PTL_M1
XTHmitll_XORT__clkbuf_4_t12 THmitll_XORT__clkbuf_4_12 THmitll_XORT__clkbuf_4_13 PTL_M1
XTHmitll_XORT__clkbuf_4_t13 THmitll_XORT__clkbuf_4_13 THmitll_XORT__clkbuf_4_14 PTL_M1
XTHmitll_XORT__clkbuf_4_t14 THmitll_XORT__clkbuf_4_14 THmitll_XORT__clkbuf_4_15 PTL_M1
XTHmitll_XORT__clkbuf_4_t15 THmitll_XORT__clkbuf_4_15 THmitll_XORT__clkbuf_4_o PTLCAP_M1
Xcin__ff_1_t0 cin__ff_1_i cin__ff_1_1 PTLCAP_M1
Xcin__ff_1_t1 cin__ff_1_1 cin__ff_1_2 BEND_PTL_M1
Xcin__ff_1_t2 cin__ff_1_2 cin__ff_1_3 PTL_M1
Xcin__ff_1_t3 cin__ff_1_3 cin__ff_1_4 PTL_M1
Xcin__ff_1_t4 cin__ff_1_4 cin__ff_1_5 PTL_M1
Xcin__ff_1_t5 cin__ff_1_5 cin__ff_1_6 PTL_M1
Xcin__ff_1_t6 cin__ff_1_6 cin__ff_1_7 PTL_M1
Xcin__ff_1_t7 cin__ff_1_7 cin__ff_1_8 PTL_M1
Xcin__ff_1_t8 cin__ff_1_8 cin__ff_1_9 PTL_M1
Xcin__ff_1_t9 cin__ff_1_9 cin__ff_1_10 PTL_M1
Xcin__ff_1_t10 cin__ff_1_10 cin__ff_1_11 PTL_M1
Xcin__ff_1_t11 cin__ff_1_11 cin__ff_1_12 PTL_M1
Xcin__ff_1_t12 cin__ff_1_12 cin__ff_1_13 PTL_M1
Xcin__ff_1_t13 cin__ff_1_13 cin__ff_1_14 PTL_M1
Xcin__ff_1_t14 cin__ff_1_14 cin__ff_1_15 PTL_M1
Xcin__ff_1_t15 cin__ff_1_15 cin__ff_1_16 PTL_M1
Xcin__ff_1_t16 cin__ff_1_16 cin__ff_1_17 PTL_M1
Xcin__ff_1_t17 cin__ff_1_17 cin__ff_1_18 BEND_PTL_M1
Xcin__ff_1_t18 cin__ff_1_18 cin__ff_1_o PTLCAP_M1
XTHmitll_AND2T__clkbuf_6_t0 THmitll_AND2T__clkbuf_6_i THmitll_AND2T__clkbuf_6_1 PTLCAP_M1
XTHmitll_AND2T__clkbuf_6_t1 THmitll_AND2T__clkbuf_6_1 THmitll_AND2T__clkbuf_6_2 BEND_PTL_M1
XTHmitll_AND2T__clkbuf_6_t2 THmitll_AND2T__clkbuf_6_2 THmitll_AND2T__clkbuf_6_3 PTL_M1
XTHmitll_AND2T__clkbuf_6_t3 THmitll_AND2T__clkbuf_6_3 THmitll_AND2T__clkbuf_6_4 PTL_M1
XTHmitll_AND2T__clkbuf_6_t4 THmitll_AND2T__clkbuf_6_4 THmitll_AND2T__clkbuf_6_5 PTL_M1
XTHmitll_AND2T__clkbuf_6_t5 THmitll_AND2T__clkbuf_6_5 THmitll_AND2T__clkbuf_6_6 PTL_M1
XTHmitll_AND2T__clkbuf_6_t6 THmitll_AND2T__clkbuf_6_6 THmitll_AND2T__clkbuf_6_7 PTL_M1
XTHmitll_AND2T__clkbuf_6_t7 THmitll_AND2T__clkbuf_6_7 THmitll_AND2T__clkbuf_6_8 PTL_M1
XTHmitll_AND2T__clkbuf_6_t8 THmitll_AND2T__clkbuf_6_8 THmitll_AND2T__clkbuf_6_9 PTL_M1
XTHmitll_AND2T__clkbuf_6_t9 THmitll_AND2T__clkbuf_6_9 THmitll_AND2T__clkbuf_6_10 PTL_M1
XTHmitll_AND2T__clkbuf_6_t10 THmitll_AND2T__clkbuf_6_10 THmitll_AND2T__clkbuf_6_11 PTL_M1
XTHmitll_AND2T__clkbuf_6_t11 THmitll_AND2T__clkbuf_6_11 THmitll_AND2T__clkbuf_6_12 BEND_PTL_M1
XTHmitll_AND2T__clkbuf_6_t12 THmitll_AND2T__clkbuf_6_12 THmitll_AND2T__clkbuf_6_13 PTL_M1
XTHmitll_AND2T__clkbuf_6_t13 THmitll_AND2T__clkbuf_6_13 THmitll_AND2T__clkbuf_6_14 PTL_M1
XTHmitll_AND2T__clkbuf_6_t14 THmitll_AND2T__clkbuf_6_14 THmitll_AND2T__clkbuf_6_15 PTL_M1
XTHmitll_AND2T__clkbuf_6_t15 THmitll_AND2T__clkbuf_6_15 THmitll_AND2T__clkbuf_6_16 PTL_M1
XTHmitll_AND2T__clkbuf_6_t16 THmitll_AND2T__clkbuf_6_16 THmitll_AND2T__clkbuf_6_17 BEND_PTL_M1
XTHmitll_AND2T__clkbuf_6_t17 THmitll_AND2T__clkbuf_6_17 THmitll_AND2T__clkbuf_6_18 PTL_M1
XTHmitll_AND2T__clkbuf_6_t18 THmitll_AND2T__clkbuf_6_18 THmitll_AND2T__clkbuf_6_o PTLCAP_M1
XTHmitll_AND2T__clkbuf_3_t0 THmitll_AND2T__clkbuf_3_i THmitll_AND2T__clkbuf_3_1 PTLCAP_M1
XTHmitll_AND2T__clkbuf_3_t1 THmitll_AND2T__clkbuf_3_1 THmitll_AND2T__clkbuf_3_2 BEND_PTL_M1
XTHmitll_AND2T__clkbuf_3_t2 THmitll_AND2T__clkbuf_3_2 THmitll_AND2T__clkbuf_3_3 PTL_M1
XTHmitll_AND2T__clkbuf_3_t3 THmitll_AND2T__clkbuf_3_3 THmitll_AND2T__clkbuf_3_4 PTL_M1
XTHmitll_AND2T__clkbuf_3_t4 THmitll_AND2T__clkbuf_3_4 THmitll_AND2T__clkbuf_3_5 PTL_M1
XTHmitll_AND2T__clkbuf_3_t5 THmitll_AND2T__clkbuf_3_5 THmitll_AND2T__clkbuf_3_6 PTL_M1
XTHmitll_AND2T__clkbuf_3_t6 THmitll_AND2T__clkbuf_3_6 THmitll_AND2T__clkbuf_3_7 PTL_M1
XTHmitll_AND2T__clkbuf_3_t7 THmitll_AND2T__clkbuf_3_7 THmitll_AND2T__clkbuf_3_8 PTL_M1
XTHmitll_AND2T__clkbuf_3_t8 THmitll_AND2T__clkbuf_3_8 THmitll_AND2T__clkbuf_3_9 PTL_M1
XTHmitll_AND2T__clkbuf_3_t9 THmitll_AND2T__clkbuf_3_9 THmitll_AND2T__clkbuf_3_10 PTL_M1
XTHmitll_AND2T__clkbuf_3_t10 THmitll_AND2T__clkbuf_3_10 THmitll_AND2T__clkbuf_3_11 PTL_M1
XTHmitll_AND2T__clkbuf_3_t11 THmitll_AND2T__clkbuf_3_11 THmitll_AND2T__clkbuf_3_12 BEND_PTL_M1
XTHmitll_AND2T__clkbuf_3_t12 THmitll_AND2T__clkbuf_3_12 THmitll_AND2T__clkbuf_3_13 PTL_M1
XTHmitll_AND2T__clkbuf_3_t13 THmitll_AND2T__clkbuf_3_13 THmitll_AND2T__clkbuf_3_14 PTL_M1
XTHmitll_AND2T__clkbuf_3_t14 THmitll_AND2T__clkbuf_3_14 THmitll_AND2T__clkbuf_3_15 PTL_M1
XTHmitll_AND2T__clkbuf_3_t15 THmitll_AND2T__clkbuf_3_15 THmitll_AND2T__clkbuf_3_16 PTL_M1
XTHmitll_AND2T__clkbuf_3_t16 THmitll_AND2T__clkbuf_3_16 THmitll_AND2T__clkbuf_3_17 BEND_PTL_M1
XTHmitll_AND2T__clkbuf_3_t17 THmitll_AND2T__clkbuf_3_17 THmitll_AND2T__clkbuf_3_18 PTL_M1
XTHmitll_AND2T__clkbuf_3_t18 THmitll_AND2T__clkbuf_3_18 THmitll_AND2T__clkbuf_3_o PTLCAP_M1
XTHmitll_OR2T__clkbuf_1_t0 THmitll_OR2T__clkbuf_1_i THmitll_OR2T__clkbuf_1_1 PTLCAP_M1
XTHmitll_OR2T__clkbuf_1_t1 THmitll_OR2T__clkbuf_1_1 THmitll_OR2T__clkbuf_1_2 PTL_M1
XTHmitll_OR2T__clkbuf_1_t2 THmitll_OR2T__clkbuf_1_2 THmitll_OR2T__clkbuf_1_3 BEND_PTL_M1
XTHmitll_OR2T__clkbuf_1_t3 THmitll_OR2T__clkbuf_1_3 THmitll_OR2T__clkbuf_1_4 PTL_M1
XTHmitll_OR2T__clkbuf_1_t4 THmitll_OR2T__clkbuf_1_4 THmitll_OR2T__clkbuf_1_5 PTL_M1
XTHmitll_OR2T__clkbuf_1_t5 THmitll_OR2T__clkbuf_1_5 THmitll_OR2T__clkbuf_1_6 PTL_M1
XTHmitll_OR2T__clkbuf_1_t6 THmitll_OR2T__clkbuf_1_6 THmitll_OR2T__clkbuf_1_7 PTL_M1
XTHmitll_OR2T__clkbuf_1_t7 THmitll_OR2T__clkbuf_1_7 THmitll_OR2T__clkbuf_1_8 PTL_M1
XTHmitll_OR2T__clkbuf_1_t8 THmitll_OR2T__clkbuf_1_8 THmitll_OR2T__clkbuf_1_9 PTL_M1
XTHmitll_OR2T__clkbuf_1_t9 THmitll_OR2T__clkbuf_1_9 THmitll_OR2T__clkbuf_1_10 PTL_M1
XTHmitll_OR2T__clkbuf_1_t10 THmitll_OR2T__clkbuf_1_10 THmitll_OR2T__clkbuf_1_11 PTL_M1
XTHmitll_OR2T__clkbuf_1_t11 THmitll_OR2T__clkbuf_1_11 THmitll_OR2T__clkbuf_1_12 PTL_M1
XTHmitll_OR2T__clkbuf_1_t12 THmitll_OR2T__clkbuf_1_12 THmitll_OR2T__clkbuf_1_13 PTL_M1
XTHmitll_OR2T__clkbuf_1_t13 THmitll_OR2T__clkbuf_1_13 THmitll_OR2T__clkbuf_1_14 PTL_M1
XTHmitll_OR2T__clkbuf_1_t14 THmitll_OR2T__clkbuf_1_14 THmitll_OR2T__clkbuf_1_15 PTL_M1
XTHmitll_OR2T__clkbuf_1_t15 THmitll_OR2T__clkbuf_1_15 THmitll_OR2T__clkbuf_1_16 PTL_M1
XTHmitll_OR2T__clkbuf_1_t16 THmitll_OR2T__clkbuf_1_16 THmitll_OR2T__clkbuf_1_17 PTL_M1
XTHmitll_OR2T__clkbuf_1_t17 THmitll_OR2T__clkbuf_1_17 THmitll_OR2T__clkbuf_1_18 BEND_PTL_M1
XTHmitll_OR2T__clkbuf_1_t18 THmitll_OR2T__clkbuf_1_18 THmitll_OR2T__clkbuf_1_o PTLCAP_M1
Xclk_row_1__spl_1_t0 clk_row_1__spl_1_i clk_row_1__spl_1_1 PTLCAP_M1
Xclk_row_1__spl_1_t1 clk_row_1__spl_1_1 clk_row_1__spl_1_2 PTL_M1
Xclk_row_1__spl_1_t2 clk_row_1__spl_1_2 clk_row_1__spl_1_3 PTL_M1
Xclk_row_1__spl_1_t3 clk_row_1__spl_1_3 clk_row_1__spl_1_4 PTL_M1
Xclk_row_1__spl_1_t4 clk_row_1__spl_1_4 clk_row_1__spl_1_5 PTL_M1
Xclk_row_1__spl_1_t5 clk_row_1__spl_1_5 clk_row_1__spl_1_6 PTL_M1
Xclk_row_1__spl_1_t6 clk_row_1__spl_1_6 clk_row_1__spl_1_7 PTL_M1
Xclk_row_1__spl_1_t7 clk_row_1__spl_1_7 clk_row_1__spl_1_8 PTL_M1
Xclk_row_1__spl_1_t8 clk_row_1__spl_1_8 clk_row_1__spl_1_9 PTL_M1
Xclk_row_1__spl_1_t9 clk_row_1__spl_1_9 clk_row_1__spl_1_10 PTL_M1
Xclk_row_1__spl_1_t10 clk_row_1__spl_1_10 clk_row_1__spl_1_11 PTL_M1
Xclk_row_1__spl_1_t11 clk_row_1__spl_1_11 clk_row_1__spl_1_12 BEND_PTL_M1
Xclk_row_1__spl_1_t12 clk_row_1__spl_1_12 clk_row_1__spl_1_13 PTL_M1
Xclk_row_1__spl_1_t13 clk_row_1__spl_1_13 clk_row_1__spl_1_14 PTL_M1
Xclk_row_1__spl_1_t14 clk_row_1__spl_1_14 clk_row_1__spl_1_15 PTL_M1
Xclk_row_1__spl_1_t15 clk_row_1__spl_1_15 clk_row_1__spl_1_16 PTL_M1
Xclk_row_1__spl_1_t16 clk_row_1__spl_1_16 clk_row_1__spl_1_o PTLCAP_M1
Xa0__spl_9_t0 a0__spl_9_i a0__spl_9_1 PTLCAP_M1
Xa0__spl_9_t1 a0__spl_9_1 a0__spl_9_2 PTL_M1
Xa0__spl_9_t2 a0__spl_9_2 a0__spl_9_3 PTL_M1
Xa0__spl_9_t3 a0__spl_9_3 a0__spl_9_4 BEND_PTL_M1
Xa0__spl_9_t4 a0__spl_9_4 a0__spl_9_5 PTL_M1
Xa0__spl_9_t5 a0__spl_9_5 a0__spl_9_6 PTL_M1
Xa0__spl_9_t6 a0__spl_9_6 a0__spl_9_7 PTL_M1
Xa0__spl_9_t7 a0__spl_9_7 a0__spl_9_8 PTL_M1
Xa0__spl_9_t8 a0__spl_9_8 a0__spl_9_9 PTL_M1
Xa0__spl_9_t9 a0__spl_9_9 a0__spl_9_10 PTL_M1
Xa0__spl_9_t10 a0__spl_9_10 a0__spl_9_11 PTL_M1
Xa0__spl_9_t11 a0__spl_9_11 a0__spl_9_12 PTL_M1
Xa0__spl_9_t12 a0__spl_9_12 a0__spl_9_13 PTL_M1
Xa0__spl_9_t13 a0__spl_9_13 a0__spl_9_14 PTL_M1
Xa0__spl_9_t14 a0__spl_9_14 a0__spl_9_15 PTL_M1
Xa0__spl_9_t15 a0__spl_9_15 a0__spl_9_16 PTL_M1
Xa0__spl_9_t16 a0__spl_9_16 a0__spl_9_17 PTL_M1
Xa0__spl_9_t17 a0__spl_9_17 a0__spl_9_o PTLCAP_M1
Xx1__spl_12__ff_5_t0 x1__spl_12__ff_5_i x1__spl_12__ff_5_1 PTLCAP_M1
Xx1__spl_12__ff_5_t1 x1__spl_12__ff_5_1 x1__spl_12__ff_5_2 BEND_PTL_M1
Xx1__spl_12__ff_5_t2 x1__spl_12__ff_5_2 x1__spl_12__ff_5_3 PTL_M1
Xx1__spl_12__ff_5_t3 x1__spl_12__ff_5_3 x1__spl_12__ff_5_4 PTL_M1
Xx1__spl_12__ff_5_t4 x1__spl_12__ff_5_4 x1__spl_12__ff_5_5 PTL_M1
Xx1__spl_12__ff_5_t5 x1__spl_12__ff_5_5 x1__spl_12__ff_5_6 PTL_M1
Xx1__spl_12__ff_5_t6 x1__spl_12__ff_5_6 x1__spl_12__ff_5_7 PTL_M1
Xx1__spl_12__ff_5_t7 x1__spl_12__ff_5_7 x1__spl_12__ff_5_8 PTL_M1
Xx1__spl_12__ff_5_t8 x1__spl_12__ff_5_8 x1__spl_12__ff_5_9 PTL_M1
Xx1__spl_12__ff_5_t9 x1__spl_12__ff_5_9 x1__spl_12__ff_5_10 PTL_M1
Xx1__spl_12__ff_5_t10 x1__spl_12__ff_5_10 x1__spl_12__ff_5_11 BEND_PTL_M1
Xx1__spl_12__ff_5_t11 x1__spl_12__ff_5_11 x1__spl_12__ff_5_12 BEND_PTL_M1
Xx1__spl_12__ff_5_t12 x1__spl_12__ff_5_12 x1__spl_12__ff_5_13 PTL_M1
Xx1__spl_12__ff_5_t13 x1__spl_12__ff_5_13 x1__spl_12__ff_5_14 PTL_M1
Xx1__spl_12__ff_5_t14 x1__spl_12__ff_5_14 x1__spl_12__ff_5_15 PTL_M1
Xx1__spl_12__ff_5_t15 x1__spl_12__ff_5_15 x1__spl_12__ff_5_16 PTL_M1
Xx1__spl_12__ff_5_t16 x1__spl_12__ff_5_16 x1__spl_12__ff_5_17 PTL_M1
Xx1__spl_12__ff_5_t17 x1__spl_12__ff_5_17 x1__spl_12__ff_5_18 PTL_M1
Xx1__spl_12__ff_5_t18 x1__spl_12__ff_5_18 x1__spl_12__ff_5_19 BEND_PTL_M1
Xx1__spl_12__ff_5_t19 x1__spl_12__ff_5_19 x1__spl_12__ff_5_o PTLCAP_M1
Xclk_row_5__spl_3_t0 clk_row_5__spl_3_i clk_row_5__spl_3_1 PTLCAP_M1
Xclk_row_5__spl_3_t1 clk_row_5__spl_3_1 clk_row_5__spl_3_2 PTL_M1
Xclk_row_5__spl_3_t2 clk_row_5__spl_3_2 clk_row_5__spl_3_3 PTL_M1
Xclk_row_5__spl_3_t3 clk_row_5__spl_3_3 clk_row_5__spl_3_4 PTL_M1
Xclk_row_5__spl_3_t4 clk_row_5__spl_3_4 clk_row_5__spl_3_5 PTL_M1
Xclk_row_5__spl_3_t5 clk_row_5__spl_3_5 clk_row_5__spl_3_6 PTL_M1
Xclk_row_5__spl_3_t6 clk_row_5__spl_3_6 clk_row_5__spl_3_7 PTL_M1
Xclk_row_5__spl_3_t7 clk_row_5__spl_3_7 clk_row_5__spl_3_8 PTL_M1
Xclk_row_5__spl_3_t8 clk_row_5__spl_3_8 clk_row_5__spl_3_9 PTL_M1
Xclk_row_5__spl_3_t9 clk_row_5__spl_3_9 clk_row_5__spl_3_10 PTL_M1
Xclk_row_5__spl_3_t10 clk_row_5__spl_3_10 clk_row_5__spl_3_11 BEND_PTL_M1
Xclk_row_5__spl_3_t11 clk_row_5__spl_3_11 clk_row_5__spl_3_12 PTL_M1
Xclk_row_5__spl_3_t12 clk_row_5__spl_3_12 clk_row_5__spl_3_13 PTL_M1
Xclk_row_5__spl_3_t13 clk_row_5__spl_3_13 clk_row_5__spl_3_14 PTL_M1
Xclk_row_5__spl_3_t14 clk_row_5__spl_3_14 clk_row_5__spl_3_15 PTL_M1
Xclk_row_5__spl_3_t15 clk_row_5__spl_3_15 clk_row_5__spl_3_16 PTL_M1
Xclk_row_5__spl_3_t16 clk_row_5__spl_3_16 clk_row_5__spl_3_17 PTL_M1
Xclk_row_5__spl_3_t17 clk_row_5__spl_3_17 clk_row_5__spl_3_o PTLCAP_M1
Xclk_row_5__spl_2_t0 clk_row_5__spl_2_i clk_row_5__spl_2_1 PTLCAP_M1
Xclk_row_5__spl_2_t1 clk_row_5__spl_2_1 clk_row_5__spl_2_2 PTL_M1
Xclk_row_5__spl_2_t2 clk_row_5__spl_2_2 clk_row_5__spl_2_3 PTL_M1
Xclk_row_5__spl_2_t3 clk_row_5__spl_2_3 clk_row_5__spl_2_4 PTL_M1
Xclk_row_5__spl_2_t4 clk_row_5__spl_2_4 clk_row_5__spl_2_5 PTL_M1
Xclk_row_5__spl_2_t5 clk_row_5__spl_2_5 clk_row_5__spl_2_6 PTL_M1
Xclk_row_5__spl_2_t6 clk_row_5__spl_2_6 clk_row_5__spl_2_7 PTL_M1
Xclk_row_5__spl_2_t7 clk_row_5__spl_2_7 clk_row_5__spl_2_8 PTL_M1
Xclk_row_5__spl_2_t8 clk_row_5__spl_2_8 clk_row_5__spl_2_9 PTL_M1
Xclk_row_5__spl_2_t9 clk_row_5__spl_2_9 clk_row_5__spl_2_10 BEND_PTL_M1
Xclk_row_5__spl_2_t10 clk_row_5__spl_2_10 clk_row_5__spl_2_11 PTL_M1
Xclk_row_5__spl_2_t11 clk_row_5__spl_2_11 clk_row_5__spl_2_12 PTL_M1
Xclk_row_5__spl_2_t12 clk_row_5__spl_2_12 clk_row_5__spl_2_13 PTL_M1
Xclk_row_5__spl_2_t13 clk_row_5__spl_2_13 clk_row_5__spl_2_14 PTL_M1
Xclk_row_5__spl_2_t14 clk_row_5__spl_2_14 clk_row_5__spl_2_15 PTL_M1
Xclk_row_5__spl_2_t15 clk_row_5__spl_2_15 clk_row_5__spl_2_16 PTL_M1
Xclk_row_5__spl_2_t16 clk_row_5__spl_2_16 clk_row_5__spl_2_17 PTL_M1
Xclk_row_5__spl_2_t17 clk_row_5__spl_2_17 clk_row_5__spl_2_o PTLCAP_M1
Xa1__spl_13_t0 a1__spl_13_i a1__spl_13_1 PTLCAP_M1
Xa1__spl_13_t1 a1__spl_13_1 a1__spl_13_2 PTL_M1
Xa1__spl_13_t2 a1__spl_13_2 a1__spl_13_3 PTL_M1
Xa1__spl_13_t3 a1__spl_13_3 a1__spl_13_4 BEND_PTL_M1
Xa1__spl_13_t4 a1__spl_13_4 a1__spl_13_5 PTL_M1
Xa1__spl_13_t5 a1__spl_13_5 a1__spl_13_6 PTL_M1
Xa1__spl_13_t6 a1__spl_13_6 a1__spl_13_7 PTL_M1
Xa1__spl_13_t7 a1__spl_13_7 a1__spl_13_8 PTL_M1
Xa1__spl_13_t8 a1__spl_13_8 a1__spl_13_9 PTL_M1
Xa1__spl_13_t9 a1__spl_13_9 a1__spl_13_10 PTL_M1
Xa1__spl_13_t10 a1__spl_13_10 a1__spl_13_11 PTL_M1
Xa1__spl_13_t11 a1__spl_13_11 a1__spl_13_12 PTL_M1
Xa1__spl_13_t12 a1__spl_13_12 a1__spl_13_13 PTL_M1
Xa1__spl_13_t13 a1__spl_13_13 a1__spl_13_14 PTL_M1
Xa1__spl_13_t14 a1__spl_13_14 a1__spl_13_15 PTL_M1
Xa1__spl_13_t15 a1__spl_13_15 a1__spl_13_16 PTL_M1
Xa1__spl_13_t16 a1__spl_13_16 a1__spl_13_17 PTL_M1
Xa1__spl_13_t17 a1__spl_13_17 a1__spl_13_o PTLCAP_M1
Xclk_row_2__spl_2_t0 clk_row_2__spl_2_i clk_row_2__spl_2_1 PTLCAP_M1
Xclk_row_2__spl_2_t1 clk_row_2__spl_2_1 clk_row_2__spl_2_2 PTL_M1
Xclk_row_2__spl_2_t2 clk_row_2__spl_2_2 clk_row_2__spl_2_3 PTL_M1
Xclk_row_2__spl_2_t3 clk_row_2__spl_2_3 clk_row_2__spl_2_4 PTL_M1
Xclk_row_2__spl_2_t4 clk_row_2__spl_2_4 clk_row_2__spl_2_5 PTL_M1
Xclk_row_2__spl_2_t5 clk_row_2__spl_2_5 clk_row_2__spl_2_6 PTL_M1
Xclk_row_2__spl_2_t6 clk_row_2__spl_2_6 clk_row_2__spl_2_7 PTL_M1
Xclk_row_2__spl_2_t7 clk_row_2__spl_2_7 clk_row_2__spl_2_8 PTL_M1
Xclk_row_2__spl_2_t8 clk_row_2__spl_2_8 clk_row_2__spl_2_9 PTL_M1
Xclk_row_2__spl_2_t9 clk_row_2__spl_2_9 clk_row_2__spl_2_10 PTL_M1
Xclk_row_2__spl_2_t10 clk_row_2__spl_2_10 clk_row_2__spl_2_11 BEND_PTL_M1
Xclk_row_2__spl_2_t11 clk_row_2__spl_2_11 clk_row_2__spl_2_12 PTL_M1
Xclk_row_2__spl_2_t12 clk_row_2__spl_2_12 clk_row_2__spl_2_13 PTL_M1
Xclk_row_2__spl_2_t13 clk_row_2__spl_2_13 clk_row_2__spl_2_14 PTL_M1
Xclk_row_2__spl_2_t14 clk_row_2__spl_2_14 clk_row_2__spl_2_15 BEND_PTL_M1
Xclk_row_2__spl_2_t15 clk_row_2__spl_2_15 clk_row_2__spl_2_16 PTL_M1
Xclk_row_2__spl_2_t16 clk_row_2__spl_2_16 clk_row_2__spl_2_17 PTL_M1
Xclk_row_2__spl_2_t17 clk_row_2__spl_2_17 clk_row_2__spl_2_18 BEND_PTL_M1
Xclk_row_2__spl_2_t18 clk_row_2__spl_2_18 clk_row_2__spl_2_o PTLCAP_M1
Xclk_row_2__spl_1_t0 clk_row_2__spl_1_i clk_row_2__spl_1_1 PTLCAP_M1
Xclk_row_2__spl_1_t1 clk_row_2__spl_1_1 clk_row_2__spl_1_2 BEND_PTL_M1
Xclk_row_2__spl_1_t2 clk_row_2__spl_1_2 clk_row_2__spl_1_3 PTL_M1
Xclk_row_2__spl_1_t3 clk_row_2__spl_1_3 clk_row_2__spl_1_4 PTL_M1
Xclk_row_2__spl_1_t4 clk_row_2__spl_1_4 clk_row_2__spl_1_5 PTL_M1
Xclk_row_2__spl_1_t5 clk_row_2__spl_1_5 clk_row_2__spl_1_6 PTL_M1
Xclk_row_2__spl_1_t6 clk_row_2__spl_1_6 clk_row_2__spl_1_7 PTL_M1
Xclk_row_2__spl_1_t7 clk_row_2__spl_1_7 clk_row_2__spl_1_8 BEND_PTL_M1
Xclk_row_2__spl_1_t8 clk_row_2__spl_1_8 clk_row_2__spl_1_9 PTL_M1
Xclk_row_2__spl_1_t9 clk_row_2__spl_1_9 clk_row_2__spl_1_10 PTL_M1
Xclk_row_2__spl_1_t10 clk_row_2__spl_1_10 clk_row_2__spl_1_11 PTL_M1
Xclk_row_2__spl_1_t11 clk_row_2__spl_1_11 clk_row_2__spl_1_12 PTL_M1
Xclk_row_2__spl_1_t12 clk_row_2__spl_1_12 clk_row_2__spl_1_13 PTL_M1
Xclk_row_2__spl_1_t13 clk_row_2__spl_1_13 clk_row_2__spl_1_14 PTL_M1
Xclk_row_2__spl_1_t14 clk_row_2__spl_1_14 clk_row_2__spl_1_15 PTL_M1
Xclk_row_2__spl_1_t15 clk_row_2__spl_1_15 clk_row_2__spl_1_16 PTL_M1
Xclk_row_2__spl_1_t16 clk_row_2__spl_1_16 clk_row_2__spl_1_17 PTL_M1
Xclk_row_2__spl_1_t17 clk_row_2__spl_1_17 clk_row_2__spl_1_18 PTL_M1
Xclk_row_2__spl_1_t18 clk_row_2__spl_1_18 clk_row_2__spl_1_19 PTL_M1
Xclk_row_2__spl_1_t19 clk_row_2__spl_1_19 clk_row_2__spl_1_20 BEND_PTL_M1
Xclk_row_2__spl_1_t20 clk_row_2__spl_1_20 clk_row_2__spl_1_o PTLCAP_M1
Xclk_row_4__spl_6_t0 clk_row_4__spl_6_i clk_row_4__spl_6_1 PTLCAP_M1
Xclk_row_4__spl_6_t1 clk_row_4__spl_6_1 clk_row_4__spl_6_2 PTL_M1
Xclk_row_4__spl_6_t2 clk_row_4__spl_6_2 clk_row_4__spl_6_3 PTL_M1
Xclk_row_4__spl_6_t3 clk_row_4__spl_6_3 clk_row_4__spl_6_4 PTL_M1
Xclk_row_4__spl_6_t4 clk_row_4__spl_6_4 clk_row_4__spl_6_5 PTL_M1
Xclk_row_4__spl_6_t5 clk_row_4__spl_6_5 clk_row_4__spl_6_6 BEND_PTL_M1
Xclk_row_4__spl_6_t6 clk_row_4__spl_6_6 clk_row_4__spl_6_7 PTL_M1
Xclk_row_4__spl_6_t7 clk_row_4__spl_6_7 clk_row_4__spl_6_8 PTL_M1
Xclk_row_4__spl_6_t8 clk_row_4__spl_6_8 clk_row_4__spl_6_9 PTL_M1
Xclk_row_4__spl_6_t9 clk_row_4__spl_6_9 clk_row_4__spl_6_10 PTL_M1
Xclk_row_4__spl_6_t10 clk_row_4__spl_6_10 clk_row_4__spl_6_11 PTL_M1
Xclk_row_4__spl_6_t11 clk_row_4__spl_6_11 clk_row_4__spl_6_12 PTL_M1
Xclk_row_4__spl_6_t12 clk_row_4__spl_6_12 clk_row_4__spl_6_13 PTL_M1
Xclk_row_4__spl_6_t13 clk_row_4__spl_6_13 clk_row_4__spl_6_14 PTL_M1
Xclk_row_4__spl_6_t14 clk_row_4__spl_6_14 clk_row_4__spl_6_15 PTL_M1
Xclk_row_4__spl_6_t15 clk_row_4__spl_6_15 clk_row_4__spl_6_16 BEND_PTL_M1
Xclk_row_4__spl_6_t16 clk_row_4__spl_6_16 clk_row_4__spl_6_17 PTL_M1
Xclk_row_4__spl_6_t17 clk_row_4__spl_6_17 clk_row_4__spl_6_18 PTL_M1
Xclk_row_4__spl_6_t18 clk_row_4__spl_6_18 clk_row_4__spl_6_o PTLCAP_M1
Xa0__spl_10_t0 a0__spl_10_i a0__spl_10_1 PTLCAP_M1
Xa0__spl_10_t1 a0__spl_10_1 a0__spl_10_2 PTL_M1
Xa0__spl_10_t2 a0__spl_10_2 a0__spl_10_3 PTL_M1
Xa0__spl_10_t3 a0__spl_10_3 a0__spl_10_4 PTL_M1
Xa0__spl_10_t4 a0__spl_10_4 a0__spl_10_5 BEND_PTL_M1
Xa0__spl_10_t5 a0__spl_10_5 a0__spl_10_6 PTL_M1
Xa0__spl_10_t6 a0__spl_10_6 a0__spl_10_7 PTL_M1
Xa0__spl_10_t7 a0__spl_10_7 a0__spl_10_8 PTL_M1
Xa0__spl_10_t8 a0__spl_10_8 a0__spl_10_9 PTL_M1
Xa0__spl_10_t9 a0__spl_10_9 a0__spl_10_10 PTL_M1
Xa0__spl_10_t10 a0__spl_10_10 a0__spl_10_11 PTL_M1
Xa0__spl_10_t11 a0__spl_10_11 a0__spl_10_12 PTL_M1
Xa0__spl_10_t12 a0__spl_10_12 a0__spl_10_13 PTL_M1
Xa0__spl_10_t13 a0__spl_10_13 a0__spl_10_14 PTL_M1
Xa0__spl_10_t14 a0__spl_10_14 a0__spl_10_15 PTL_M1
Xa0__spl_10_t15 a0__spl_10_15 a0__spl_10_16 PTL_M1
Xa0__spl_10_t16 a0__spl_10_16 a0__spl_10_17 PTL_M1
Xa0__spl_10_t17 a0__spl_10_17 a0__spl_10_18 PTL_M1
Xa0__spl_10_t18 a0__spl_10_18 a0__spl_10_19 PTL_M1
Xa0__spl_10_t19 a0__spl_10_19 a0__spl_10_o PTLCAP_M1
Xclk_row_3_t0 clk_row_3_i clk_row_3_1 PTLCAP_M1
Xclk_row_3_t1 clk_row_3_1 clk_row_3_2 PTL_M1
Xclk_row_3_t2 clk_row_3_2 clk_row_3_3 PTL_M1
Xclk_row_3_t3 clk_row_3_3 clk_row_3_4 BEND_PTL_M1
Xclk_row_3_t4 clk_row_3_4 clk_row_3_5 PTL_M1
Xclk_row_3_t5 clk_row_3_5 clk_row_3_6 PTL_M1
Xclk_row_3_t6 clk_row_3_6 clk_row_3_7 PTL_M1
Xclk_row_3_t7 clk_row_3_7 clk_row_3_8 PTL_M1
Xclk_row_3_t8 clk_row_3_8 clk_row_3_9 PTL_M1
Xclk_row_3_t9 clk_row_3_9 clk_row_3_10 PTL_M1
Xclk_row_3_t10 clk_row_3_10 clk_row_3_11 PTL_M1
Xclk_row_3_t11 clk_row_3_11 clk_row_3_12 PTL_M1
Xclk_row_3_t12 clk_row_3_12 clk_row_3_13 PTL_M1
Xclk_row_3_t13 clk_row_3_13 clk_row_3_14 PTL_M1
Xclk_row_3_t14 clk_row_3_14 clk_row_3_15 PTL_M1
Xclk_row_3_t15 clk_row_3_15 clk_row_3_16 PTL_M1
Xclk_row_3_t16 clk_row_3_16 clk_row_3_17 PTL_M1
Xclk_row_3_t17 clk_row_3_17 clk_row_3_18 PTL_M1
Xclk_row_3_t18 clk_row_3_18 clk_row_3_19 PTL_M1
Xclk_row_3_t19 clk_row_3_19 clk_row_3_o PTLCAP_M1
Xb0_t0 b0_i b0_1 PTLCAP_M1
Xb0_t1 b0_1 b0_2 PTL_M1
Xb0_t2 b0_2 b0_3 PTL_M1
Xb0_t3 b0_3 b0_4 PTL_M1
Xb0_t4 b0_4 b0_5 PTL_M1
Xb0_t5 b0_5 b0_6 PTL_M1
Xb0_t6 b0_6 b0_7 PTL_M1
Xb0_t7 b0_7 b0_8 PTL_M1
Xb0_t8 b0_8 b0_9 BEND_PTL_M1
Xb0_t9 b0_9 b0_10 PTL_M1
Xb0_t10 b0_10 b0_11 PTL_M1
Xb0_t11 b0_11 b0_12 PTL_M1
Xb0_t12 b0_12 b0_13 PTL_M1
Xb0_t13 b0_13 b0_14 PTL_M1
Xb0_t14 b0_14 b0_15 PTL_M1
Xb0_t15 b0_15 b0_16 PTL_M1
Xb0_t16 b0_16 b0_17 PTL_M1
Xb0_t17 b0_17 b0_18 PTL_M1
Xb0_t18 b0_18 b0_19 BEND_PTL_M1
Xb0_t19 b0_19 b0_o PTLCAP_M1
Xclk_row_1__spl_6_t0 clk_row_1__spl_6_i clk_row_1__spl_6_1 PTLCAP_M1
Xclk_row_1__spl_6_t1 clk_row_1__spl_6_1 clk_row_1__spl_6_2 PTL_M1
Xclk_row_1__spl_6_t2 clk_row_1__spl_6_2 clk_row_1__spl_6_3 PTL_M1
Xclk_row_1__spl_6_t3 clk_row_1__spl_6_3 clk_row_1__spl_6_4 PTL_M1
Xclk_row_1__spl_6_t4 clk_row_1__spl_6_4 clk_row_1__spl_6_5 PTL_M1
Xclk_row_1__spl_6_t5 clk_row_1__spl_6_5 clk_row_1__spl_6_6 PTL_M1
Xclk_row_1__spl_6_t6 clk_row_1__spl_6_6 clk_row_1__spl_6_7 PTL_M1
Xclk_row_1__spl_6_t7 clk_row_1__spl_6_7 clk_row_1__spl_6_8 PTL_M1
Xclk_row_1__spl_6_t8 clk_row_1__spl_6_8 clk_row_1__spl_6_9 PTL_M1
Xclk_row_1__spl_6_t9 clk_row_1__spl_6_9 clk_row_1__spl_6_10 PTL_M1
Xclk_row_1__spl_6_t10 clk_row_1__spl_6_10 clk_row_1__spl_6_11 PTL_M1
Xclk_row_1__spl_6_t11 clk_row_1__spl_6_11 clk_row_1__spl_6_12 PTL_M1
Xclk_row_1__spl_6_t12 clk_row_1__spl_6_12 clk_row_1__spl_6_13 PTL_M1
Xclk_row_1__spl_6_t13 clk_row_1__spl_6_13 clk_row_1__spl_6_14 BEND_PTL_M1
Xclk_row_1__spl_6_t14 clk_row_1__spl_6_14 clk_row_1__spl_6_15 PTL_M1
Xclk_row_1__spl_6_t15 clk_row_1__spl_6_15 clk_row_1__spl_6_16 PTL_M1
Xclk_row_1__spl_6_t16 clk_row_1__spl_6_16 clk_row_1__spl_6_17 PTL_M1
Xclk_row_1__spl_6_t17 clk_row_1__spl_6_17 clk_row_1__spl_6_18 PTL_M1
Xclk_row_1__spl_6_t18 clk_row_1__spl_6_18 clk_row_1__spl_6_19 PTL_M1
Xclk_row_1__spl_6_t19 clk_row_1__spl_6_19 clk_row_1__spl_6_20 PTL_M1
Xclk_row_1__spl_6_t20 clk_row_1__spl_6_20 clk_row_1__spl_6_21 PTL_M1
Xclk_row_1__spl_6_t21 clk_row_1__spl_6_21 clk_row_1__spl_6_22 PTL_M1
Xclk_row_1__spl_6_t22 clk_row_1__spl_6_22 clk_row_1__spl_6_23 PTL_M1
Xclk_row_1__spl_6_t23 clk_row_1__spl_6_23 clk_row_1__spl_6_24 PTL_M1
Xclk_row_1__spl_6_t24 clk_row_1__spl_6_24 clk_row_1__spl_6_25 PTL_M1
Xclk_row_1__spl_6_t25 clk_row_1__spl_6_25 clk_row_1__spl_6_26 PTL_M1
Xclk_row_1__spl_6_t26 clk_row_1__spl_6_26 clk_row_1__spl_6_27 PTL_M1
Xclk_row_1__spl_6_t27 clk_row_1__spl_6_27 clk_row_1__spl_6_28 PTL_M1
Xclk_row_1__spl_6_t28 clk_row_1__spl_6_28 clk_row_1__spl_6_29 BEND_PTL_M1
Xclk_row_1__spl_6_t29 clk_row_1__spl_6_29 clk_row_1__spl_6_30 PTL_M1
Xclk_row_1__spl_6_t30 clk_row_1__spl_6_30 clk_row_1__spl_6_31 PTL_M1
Xclk_row_1__spl_6_t31 clk_row_1__spl_6_31 clk_row_1__spl_6_32 PTL_M1
Xclk_row_1__spl_6_t32 clk_row_1__spl_6_32 clk_row_1__spl_6_33 PTL_M1
Xclk_row_1__spl_6_t33 clk_row_1__spl_6_33 clk_row_1__spl_6_34 PTL_M1
Xclk_row_1__spl_6_t34 clk_row_1__spl_6_34 clk_row_1__spl_6_35 PTL_M1
Xclk_row_1__spl_6_t35 clk_row_1__spl_6_35 clk_row_1__spl_6_36 PTL_M1
Xclk_row_1__spl_6_t36 clk_row_1__spl_6_36 clk_row_1__spl_6_37 PTL_M1
Xclk_row_1__spl_6_t37 clk_row_1__spl_6_37 clk_row_1__spl_6_o PTLCAP_M1
Xc1__spl_5_t0 c1__spl_5_i c1__spl_5_1 PTLCAP_M1
Xc1__spl_5_t1 c1__spl_5_1 c1__spl_5_2 BEND_PTL_M1
Xc1__spl_5_t2 c1__spl_5_2 c1__spl_5_3 PTL_M1
Xc1__spl_5_t3 c1__spl_5_3 c1__spl_5_4 PTL_M1
Xc1__spl_5_t4 c1__spl_5_4 c1__spl_5_5 PTL_M1
Xc1__spl_5_t5 c1__spl_5_5 c1__spl_5_6 BEND_PTL_M1
Xc1__spl_5_t6 c1__spl_5_6 c1__spl_5_7 PTL_M1
Xc1__spl_5_t7 c1__spl_5_7 c1__spl_5_8 PTL_M1
Xc1__spl_5_t8 c1__spl_5_8 c1__spl_5_9 PTL_M1
Xc1__spl_5_t9 c1__spl_5_9 c1__spl_5_10 PTL_M1
Xc1__spl_5_t10 c1__spl_5_10 c1__spl_5_11 PTL_M1
Xc1__spl_5_t11 c1__spl_5_11 c1__spl_5_12 PTL_M1
Xc1__spl_5_t12 c1__spl_5_12 c1__spl_5_13 BEND_PTL_M1
Xc1__spl_5_t13 c1__spl_5_13 c1__spl_5_14 PTL_M1
Xc1__spl_5_t14 c1__spl_5_14 c1__spl_5_15 PTL_M1
Xc1__spl_5_t15 c1__spl_5_15 c1__spl_5_16 PTL_M1
Xc1__spl_5_t16 c1__spl_5_16 c1__spl_5_17 PTL_M1
Xc1__spl_5_t17 c1__spl_5_17 c1__spl_5_18 PTL_M1
Xc1__spl_5_t18 c1__spl_5_18 c1__spl_5_19 PTL_M1
Xc1__spl_5_t19 c1__spl_5_19 c1__spl_5_20 PTL_M1
Xc1__spl_5_t20 c1__spl_5_20 c1__spl_5_21 PTL_M1
Xc1__spl_5_t21 c1__spl_5_21 c1__spl_5_22 PTL_M1
Xc1__spl_5_t22 c1__spl_5_22 c1__spl_5_23 BEND_PTL_M1
Xc1__spl_5_t23 c1__spl_5_23 c1__spl_5_24 PTL_M1
Xc1__spl_5_t24 c1__spl_5_24 c1__spl_5_25 PTL_M1
Xc1__spl_5_t25 c1__spl_5_25 c1__spl_5_26 PTL_M1
Xc1__spl_5_t26 c1__spl_5_26 c1__spl_5_27 PTL_M1
Xc1__spl_5_t27 c1__spl_5_27 c1__spl_5_28 PTL_M1
Xc1__spl_5_t28 c1__spl_5_28 c1__spl_5_29 PTL_M1
Xc1__spl_5_t29 c1__spl_5_29 c1__spl_5_30 PTL_M1
Xc1__spl_5_t30 c1__spl_5_30 c1__spl_5_31 PTL_M1
Xc1__spl_5_t31 c1__spl_5_31 c1__spl_5_32 PTL_M1
Xc1__spl_5_t32 c1__spl_5_32 c1__spl_5_33 PTL_M1
Xc1__spl_5_t33 c1__spl_5_33 c1__spl_5_34 PTL_M1
Xc1__spl_5_t34 c1__spl_5_34 c1__spl_5_35 BEND_PTL_M1
Xc1__spl_5_t35 c1__spl_5_35 c1__spl_5_o PTLCAP_M1
Xx1__ff_2_t0 x1__ff_2_i x1__ff_2_1 PTLCAP_M1
Xx1__ff_2_t1 x1__ff_2_1 x1__ff_2_2 BEND_PTL_M1
Xx1__ff_2_t2 x1__ff_2_2 x1__ff_2_3 PTL_M1
Xx1__ff_2_t3 x1__ff_2_3 x1__ff_2_4 PTL_M1
Xx1__ff_2_t4 x1__ff_2_4 x1__ff_2_5 PTL_M1
Xx1__ff_2_t5 x1__ff_2_5 x1__ff_2_6 PTL_M1
Xx1__ff_2_t6 x1__ff_2_6 x1__ff_2_7 PTL_M1
Xx1__ff_2_t7 x1__ff_2_7 x1__ff_2_8 PTL_M1
Xx1__ff_2_t8 x1__ff_2_8 x1__ff_2_9 PTL_M1
Xx1__ff_2_t9 x1__ff_2_9 x1__ff_2_10 PTL_M1
Xx1__ff_2_t10 x1__ff_2_10 x1__ff_2_11 PTL_M1
Xx1__ff_2_t11 x1__ff_2_11 x1__ff_2_12 PTL_M1
Xx1__ff_2_t12 x1__ff_2_12 x1__ff_2_13 PTL_M1
Xx1__ff_2_t13 x1__ff_2_13 x1__ff_2_14 PTL_M1
Xx1__ff_2_t14 x1__ff_2_14 x1__ff_2_15 PTL_M1
Xx1__ff_2_t15 x1__ff_2_15 x1__ff_2_16 PTL_M1
Xx1__ff_2_t16 x1__ff_2_16 x1__ff_2_17 BEND_PTL_M1
Xx1__ff_2_t17 x1__ff_2_17 x1__ff_2_18 PTL_M1
Xx1__ff_2_t18 x1__ff_2_18 x1__ff_2_19 PTL_M1
Xx1__ff_2_t19 x1__ff_2_19 x1__ff_2_20 PTL_M1
Xx1__ff_2_t20 x1__ff_2_20 x1__ff_2_21 PTL_M1
Xx1__ff_2_t21 x1__ff_2_21 x1__ff_2_o PTLCAP_M1
Xclk_row_2__spl_6_t0 clk_row_2__spl_6_i clk_row_2__spl_6_1 PTLCAP_M1
Xclk_row_2__spl_6_t1 clk_row_2__spl_6_1 clk_row_2__spl_6_2 PTL_M1
Xclk_row_2__spl_6_t2 clk_row_2__spl_6_2 clk_row_2__spl_6_3 PTL_M1
Xclk_row_2__spl_6_t3 clk_row_2__spl_6_3 clk_row_2__spl_6_4 PTL_M1
Xclk_row_2__spl_6_t4 clk_row_2__spl_6_4 clk_row_2__spl_6_5 PTL_M1
Xclk_row_2__spl_6_t5 clk_row_2__spl_6_5 clk_row_2__spl_6_6 PTL_M1
Xclk_row_2__spl_6_t6 clk_row_2__spl_6_6 clk_row_2__spl_6_7 PTL_M1
Xclk_row_2__spl_6_t7 clk_row_2__spl_6_7 clk_row_2__spl_6_8 PTL_M1
Xclk_row_2__spl_6_t8 clk_row_2__spl_6_8 clk_row_2__spl_6_9 PTL_M1
Xclk_row_2__spl_6_t9 clk_row_2__spl_6_9 clk_row_2__spl_6_10 PTL_M1
Xclk_row_2__spl_6_t10 clk_row_2__spl_6_10 clk_row_2__spl_6_11 PTL_M1
Xclk_row_2__spl_6_t11 clk_row_2__spl_6_11 clk_row_2__spl_6_12 PTL_M1
Xclk_row_2__spl_6_t12 clk_row_2__spl_6_12 clk_row_2__spl_6_13 PTL_M1
Xclk_row_2__spl_6_t13 clk_row_2__spl_6_13 clk_row_2__spl_6_14 BEND_PTL_M1
Xclk_row_2__spl_6_t14 clk_row_2__spl_6_14 clk_row_2__spl_6_15 PTL_M1
Xclk_row_2__spl_6_t15 clk_row_2__spl_6_15 clk_row_2__spl_6_16 PTL_M1
Xclk_row_2__spl_6_t16 clk_row_2__spl_6_16 clk_row_2__spl_6_17 PTL_M1
Xclk_row_2__spl_6_t17 clk_row_2__spl_6_17 clk_row_2__spl_6_18 PTL_M1
Xclk_row_2__spl_6_t18 clk_row_2__spl_6_18 clk_row_2__spl_6_19 PTL_M1
Xclk_row_2__spl_6_t19 clk_row_2__spl_6_19 clk_row_2__spl_6_20 PTL_M1
Xclk_row_2__spl_6_t20 clk_row_2__spl_6_20 clk_row_2__spl_6_21 PTL_M1
Xclk_row_2__spl_6_t21 clk_row_2__spl_6_21 clk_row_2__spl_6_22 PTL_M1
Xclk_row_2__spl_6_t22 clk_row_2__spl_6_22 clk_row_2__spl_6_23 PTL_M1
Xclk_row_2__spl_6_t23 clk_row_2__spl_6_23 clk_row_2__spl_6_24 PTL_M1
Xclk_row_2__spl_6_t24 clk_row_2__spl_6_24 clk_row_2__spl_6_25 PTL_M1
Xclk_row_2__spl_6_t25 clk_row_2__spl_6_25 clk_row_2__spl_6_26 PTL_M1
Xclk_row_2__spl_6_t26 clk_row_2__spl_6_26 clk_row_2__spl_6_27 PTL_M1
Xclk_row_2__spl_6_t27 clk_row_2__spl_6_27 clk_row_2__spl_6_28 PTL_M1
Xclk_row_2__spl_6_t28 clk_row_2__spl_6_28 clk_row_2__spl_6_29 BEND_PTL_M1
Xclk_row_2__spl_6_t29 clk_row_2__spl_6_29 clk_row_2__spl_6_30 PTL_M1
Xclk_row_2__spl_6_t30 clk_row_2__spl_6_30 clk_row_2__spl_6_31 PTL_M1
Xclk_row_2__spl_6_t31 clk_row_2__spl_6_31 clk_row_2__spl_6_32 PTL_M1
Xclk_row_2__spl_6_t32 clk_row_2__spl_6_32 clk_row_2__spl_6_33 PTL_M1
Xclk_row_2__spl_6_t33 clk_row_2__spl_6_33 clk_row_2__spl_6_34 PTL_M1
Xclk_row_2__spl_6_t34 clk_row_2__spl_6_34 clk_row_2__spl_6_35 PTL_M1
Xclk_row_2__spl_6_t35 clk_row_2__spl_6_35 clk_row_2__spl_6_36 PTL_M1
Xclk_row_2__spl_6_t36 clk_row_2__spl_6_36 clk_row_2__spl_6_37 PTL_M1
Xclk_row_2__spl_6_t37 clk_row_2__spl_6_37 clk_row_2__spl_6_o PTLCAP_M1
Xclk_row_5__spl_1_t0 clk_row_5__spl_1_i clk_row_5__spl_1_1 PTLCAP_M1
Xclk_row_5__spl_1_t1 clk_row_5__spl_1_1 clk_row_5__spl_1_2 BEND_PTL_M1
Xclk_row_5__spl_1_t2 clk_row_5__spl_1_2 clk_row_5__spl_1_3 PTL_M1
Xclk_row_5__spl_1_t3 clk_row_5__spl_1_3 clk_row_5__spl_1_4 PTL_M1
Xclk_row_5__spl_1_t4 clk_row_5__spl_1_4 clk_row_5__spl_1_5 PTL_M1
Xclk_row_5__spl_1_t5 clk_row_5__spl_1_5 clk_row_5__spl_1_6 BEND_PTL_M1
Xclk_row_5__spl_1_t6 clk_row_5__spl_1_6 clk_row_5__spl_1_7 BEND_PTL_M1
Xclk_row_5__spl_1_t7 clk_row_5__spl_1_7 clk_row_5__spl_1_8 PTL_M1
Xclk_row_5__spl_1_t8 clk_row_5__spl_1_8 clk_row_5__spl_1_9 PTL_M1
Xclk_row_5__spl_1_t9 clk_row_5__spl_1_9 clk_row_5__spl_1_10 PTL_M1
Xclk_row_5__spl_1_t10 clk_row_5__spl_1_10 clk_row_5__spl_1_11 PTL_M1
Xclk_row_5__spl_1_t11 clk_row_5__spl_1_11 clk_row_5__spl_1_12 BEND_PTL_M1
Xclk_row_5__spl_1_t12 clk_row_5__spl_1_12 clk_row_5__spl_1_13 PTL_M1
Xclk_row_5__spl_1_t13 clk_row_5__spl_1_13 clk_row_5__spl_1_14 PTL_M1
Xclk_row_5__spl_1_t14 clk_row_5__spl_1_14 clk_row_5__spl_1_15 PTL_M1
Xclk_row_5__spl_1_t15 clk_row_5__spl_1_15 clk_row_5__spl_1_16 PTL_M1
Xclk_row_5__spl_1_t16 clk_row_5__spl_1_16 clk_row_5__spl_1_17 PTL_M1
Xclk_row_5__spl_1_t17 clk_row_5__spl_1_17 clk_row_5__spl_1_18 PTL_M1
Xclk_row_5__spl_1_t18 clk_row_5__spl_1_18 clk_row_5__spl_1_19 PTL_M1
Xclk_row_5__spl_1_t19 clk_row_5__spl_1_19 clk_row_5__spl_1_20 PTL_M1
Xclk_row_5__spl_1_t20 clk_row_5__spl_1_20 clk_row_5__spl_1_21 PTL_M1
Xclk_row_5__spl_1_t21 clk_row_5__spl_1_21 clk_row_5__spl_1_22 PTL_M1
Xclk_row_5__spl_1_t22 clk_row_5__spl_1_22 clk_row_5__spl_1_23 PTL_M1
Xclk_row_5__spl_1_t23 clk_row_5__spl_1_23 clk_row_5__spl_1_24 PTL_M1
Xclk_row_5__spl_1_t24 clk_row_5__spl_1_24 clk_row_5__spl_1_25 PTL_M1
Xclk_row_5__spl_1_t25 clk_row_5__spl_1_25 clk_row_5__spl_1_26 BEND_PTL_M1
Xclk_row_5__spl_1_t26 clk_row_5__spl_1_26 clk_row_5__spl_1_27 PTL_M1
Xclk_row_5__spl_1_t27 clk_row_5__spl_1_27 clk_row_5__spl_1_28 PTL_M1
Xclk_row_5__spl_1_t28 clk_row_5__spl_1_28 clk_row_5__spl_1_29 PTL_M1
Xclk_row_5__spl_1_t29 clk_row_5__spl_1_29 clk_row_5__spl_1_o PTLCAP_M1
Xb0__spl_7_t0 b0__spl_7_i b0__spl_7_1 PTLCAP_M1
Xb0__spl_7_t1 b0__spl_7_1 b0__spl_7_2 PTL_M1
Xb0__spl_7_t2 b0__spl_7_2 b0__spl_7_3 BEND_PTL_M1
Xb0__spl_7_t3 b0__spl_7_3 b0__spl_7_4 PTL_M1
Xb0__spl_7_t4 b0__spl_7_4 b0__spl_7_5 PTL_M1
Xb0__spl_7_t5 b0__spl_7_5 b0__spl_7_6 PTL_M1
Xb0__spl_7_t6 b0__spl_7_6 b0__spl_7_7 PTL_M1
Xb0__spl_7_t7 b0__spl_7_7 b0__spl_7_8 PTL_M1
Xb0__spl_7_t8 b0__spl_7_8 b0__spl_7_9 PTL_M1
Xb0__spl_7_t9 b0__spl_7_9 b0__spl_7_10 PTL_M1
Xb0__spl_7_t10 b0__spl_7_10 b0__spl_7_11 PTL_M1
Xb0__spl_7_t11 b0__spl_7_11 b0__spl_7_12 PTL_M1
Xb0__spl_7_t12 b0__spl_7_12 b0__spl_7_13 PTL_M1
Xb0__spl_7_t13 b0__spl_7_13 b0__spl_7_14 PTL_M1
Xb0__spl_7_t14 b0__spl_7_14 b0__spl_7_15 PTL_M1
Xb0__spl_7_t15 b0__spl_7_15 b0__spl_7_16 PTL_M1
Xb0__spl_7_t16 b0__spl_7_16 b0__spl_7_17 PTL_M1
Xb0__spl_7_t17 b0__spl_7_17 b0__spl_7_18 BEND_PTL_M1
Xb0__spl_7_t18 b0__spl_7_18 b0__spl_7_19 PTL_M1
Xb0__spl_7_t19 b0__spl_7_19 b0__spl_7_20 PTL_M1
Xb0__spl_7_t20 b0__spl_7_20 b0__spl_7_21 PTL_M1
Xb0__spl_7_t21 b0__spl_7_21 b0__spl_7_22 BEND_PTL_M1
Xb0__spl_7_t22 b0__spl_7_22 b0__spl_7_o PTLCAP_M1
Xb0__spl_8_t0 b0__spl_8_i b0__spl_8_1 PTLCAP_M3
Xb0__spl_8_t1 b0__spl_8_1 b0__spl_8_2 PTL_M3
Xb0__spl_8_t2 b0__spl_8_2 b0__spl_8_3 PTL_M3
Xb0__spl_8_t3 b0__spl_8_3 b0__spl_8_4 PTL_M3
Xb0__spl_8_t4 b0__spl_8_4 b0__spl_8_5 PTL_M3
Xb0__spl_8_t5 b0__spl_8_5 b0__spl_8_6 BEND_PTL_M3
Xb0__spl_8_t6 b0__spl_8_6 b0__spl_8_7 PTL_M3
Xb0__spl_8_t7 b0__spl_8_7 b0__spl_8_8 PTL_M3
Xb0__spl_8_t8 b0__spl_8_8 b0__spl_8_9 PTL_M3
Xb0__spl_8_t9 b0__spl_8_9 b0__spl_8_10 PTL_M3
Xb0__spl_8_t10 b0__spl_8_10 b0__spl_8_11 PTL_M3
Xb0__spl_8_t11 b0__spl_8_11 b0__spl_8_12 PTL_M3
Xb0__spl_8_t12 b0__spl_8_12 b0__spl_8_13 PTL_M3
Xb0__spl_8_t13 b0__spl_8_13 b0__spl_8_14 PTL_M3
Xb0__spl_8_t14 b0__spl_8_14 b0__spl_8_15 PTL_M3
Xb0__spl_8_t15 b0__spl_8_15 b0__spl_8_16 PTL_M3
Xb0__spl_8_t16 b0__spl_8_16 b0__spl_8_17 PTL_M3
Xb0__spl_8_t17 b0__spl_8_17 b0__spl_8_18 PTL_M3
Xb0__spl_8_t18 b0__spl_8_18 b0__spl_8_19 PTL_M3
Xb0__spl_8_t19 b0__spl_8_19 b0__spl_8_20 PTL_M3
Xb0__spl_8_t20 b0__spl_8_20 b0__spl_8_21 PTL_M3
Xb0__spl_8_t21 b0__spl_8_21 b0__spl_8_22 PTL_M3
Xb0__spl_8_t22 b0__spl_8_22 b0__spl_8_23 PTL_M3
Xb0__spl_8_t23 b0__spl_8_23 b0__spl_8_24 PTL_M3
Xb0__spl_8_t24 b0__spl_8_24 b0__spl_8_25 PTL_M3
Xb0__spl_8_t25 b0__spl_8_25 b0__spl_8_26 BEND_PTL_M3
Xb0__spl_8_t26 b0__spl_8_26 b0__spl_8_27 PTL_M3
Xb0__spl_8_t27 b0__spl_8_27 b0__spl_8_28 VIA_M1_M3_STRAIGHT
Xb0__spl_8_t28 b0__spl_8_28 b0__spl_8_29 PTL_M1
Xb0__spl_8_t29 b0__spl_8_29 b0__spl_8_30 PTL_M1
Xb0__spl_8_t30 b0__spl_8_30 b0__spl_8_o PTLCAP_M1
Xclk_row_1__spl_3_t0 clk_row_1__spl_3_i clk_row_1__spl_3_1 PTLCAP_M1
Xclk_row_1__spl_3_t1 clk_row_1__spl_3_1 clk_row_1__spl_3_2 PTL_M1
Xclk_row_1__spl_3_t2 clk_row_1__spl_3_2 clk_row_1__spl_3_3 PTL_M1
Xclk_row_1__spl_3_t3 clk_row_1__spl_3_3 clk_row_1__spl_3_4 PTL_M1
Xclk_row_1__spl_3_t4 clk_row_1__spl_3_4 clk_row_1__spl_3_5 PTL_M1
Xclk_row_1__spl_3_t5 clk_row_1__spl_3_5 clk_row_1__spl_3_6 BEND_PTL_M1
Xclk_row_1__spl_3_t6 clk_row_1__spl_3_6 clk_row_1__spl_3_7 PTL_M1
Xclk_row_1__spl_3_t7 clk_row_1__spl_3_7 clk_row_1__spl_3_8 PTL_M1
Xclk_row_1__spl_3_t8 clk_row_1__spl_3_8 clk_row_1__spl_3_9 PTL_M1
Xclk_row_1__spl_3_t9 clk_row_1__spl_3_9 clk_row_1__spl_3_10 PTL_M1
Xclk_row_1__spl_3_t10 clk_row_1__spl_3_10 clk_row_1__spl_3_11 PTL_M1
Xclk_row_1__spl_3_t11 clk_row_1__spl_3_11 clk_row_1__spl_3_12 PTL_M1
Xclk_row_1__spl_3_t12 clk_row_1__spl_3_12 clk_row_1__spl_3_13 PTL_M1
Xclk_row_1__spl_3_t13 clk_row_1__spl_3_13 clk_row_1__spl_3_14 PTL_M1
Xclk_row_1__spl_3_t14 clk_row_1__spl_3_14 clk_row_1__spl_3_15 PTL_M1
Xclk_row_1__spl_3_t15 clk_row_1__spl_3_15 clk_row_1__spl_3_16 PTL_M1
Xclk_row_1__spl_3_t16 clk_row_1__spl_3_16 clk_row_1__spl_3_17 PTL_M1
Xclk_row_1__spl_3_t17 clk_row_1__spl_3_17 clk_row_1__spl_3_18 PTL_M1
Xclk_row_1__spl_3_t18 clk_row_1__spl_3_18 clk_row_1__spl_3_19 PTL_M1
Xclk_row_1__spl_3_t19 clk_row_1__spl_3_19 clk_row_1__spl_3_20 BEND_PTL_M1
Xclk_row_1__spl_3_t20 clk_row_1__spl_3_20 clk_row_1__spl_3_21 PTL_M1
Xclk_row_1__spl_3_t21 clk_row_1__spl_3_21 clk_row_1__spl_3_22 PTL_M1
Xclk_row_1__spl_3_t22 clk_row_1__spl_3_22 clk_row_1__spl_3_23 PTL_M1
Xclk_row_1__spl_3_t23 clk_row_1__spl_3_23 clk_row_1__spl_3_24 PTL_M1
Xclk_row_1__spl_3_t24 clk_row_1__spl_3_24 clk_row_1__spl_3_25 PTL_M1
Xclk_row_1__spl_3_t25 clk_row_1__spl_3_25 clk_row_1__spl_3_26 PTL_M1
Xclk_row_1__spl_3_t26 clk_row_1__spl_3_26 clk_row_1__spl_3_27 PTL_M1
Xclk_row_1__spl_3_t27 clk_row_1__spl_3_27 clk_row_1__spl_3_28 PTL_M1
Xclk_row_1__spl_3_t28 clk_row_1__spl_3_28 clk_row_1__spl_3_29 PTL_M1
Xclk_row_1__spl_3_t29 clk_row_1__spl_3_29 clk_row_1__spl_3_30 PTL_M1
Xclk_row_1__spl_3_t30 clk_row_1__spl_3_30 clk_row_1__spl_3_31 PTL_M1
Xclk_row_1__spl_3_t31 clk_row_1__spl_3_31 clk_row_1__spl_3_32 PTL_M1
Xclk_row_1__spl_3_t32 clk_row_1__spl_3_32 clk_row_1__spl_3_33 PTL_M1
Xclk_row_1__spl_3_t33 clk_row_1__spl_3_33 clk_row_1__spl_3_34 BEND_PTL_M1
Xclk_row_1__spl_3_t34 clk_row_1__spl_3_34 clk_row_1__spl_3_35 PTL_M1
Xclk_row_1__spl_3_t35 clk_row_1__spl_3_35 clk_row_1__spl_3_36 PTL_M1
Xclk_row_1__spl_3_t36 clk_row_1__spl_3_36 clk_row_1__spl_3_o PTLCAP_M1
Xclk_row_2__spl_4_t0 clk_row_2__spl_4_i clk_row_2__spl_4_1 PTLCAP_M1
Xclk_row_2__spl_4_t1 clk_row_2__spl_4_1 clk_row_2__spl_4_2 PTL_M1
Xclk_row_2__spl_4_t2 clk_row_2__spl_4_2 clk_row_2__spl_4_3 BEND_PTL_M1
Xclk_row_2__spl_4_t3 clk_row_2__spl_4_3 clk_row_2__spl_4_4 PTL_M1
Xclk_row_2__spl_4_t4 clk_row_2__spl_4_4 clk_row_2__spl_4_5 PTL_M1
Xclk_row_2__spl_4_t5 clk_row_2__spl_4_5 clk_row_2__spl_4_6 PTL_M1
Xclk_row_2__spl_4_t6 clk_row_2__spl_4_6 clk_row_2__spl_4_7 BEND_PTL_M1
Xclk_row_2__spl_4_t7 clk_row_2__spl_4_7 clk_row_2__spl_4_8 PTL_M1
Xclk_row_2__spl_4_t8 clk_row_2__spl_4_8 clk_row_2__spl_4_9 PTL_M1
Xclk_row_2__spl_4_t9 clk_row_2__spl_4_9 clk_row_2__spl_4_10 PTL_M1
Xclk_row_2__spl_4_t10 clk_row_2__spl_4_10 clk_row_2__spl_4_11 PTL_M1
Xclk_row_2__spl_4_t11 clk_row_2__spl_4_11 clk_row_2__spl_4_12 PTL_M1
Xclk_row_2__spl_4_t12 clk_row_2__spl_4_12 clk_row_2__spl_4_13 PTL_M1
Xclk_row_2__spl_4_t13 clk_row_2__spl_4_13 clk_row_2__spl_4_14 PTL_M1
Xclk_row_2__spl_4_t14 clk_row_2__spl_4_14 clk_row_2__spl_4_15 BEND_PTL_M1
Xclk_row_2__spl_4_t15 clk_row_2__spl_4_15 clk_row_2__spl_4_16 PTL_M1
Xclk_row_2__spl_4_t16 clk_row_2__spl_4_16 clk_row_2__spl_4_17 PTL_M1
Xclk_row_2__spl_4_t17 clk_row_2__spl_4_17 clk_row_2__spl_4_18 PTL_M1
Xclk_row_2__spl_4_t18 clk_row_2__spl_4_18 clk_row_2__spl_4_19 PTL_M1
Xclk_row_2__spl_4_t19 clk_row_2__spl_4_19 clk_row_2__spl_4_20 PTL_M1
Xclk_row_2__spl_4_t20 clk_row_2__spl_4_20 clk_row_2__spl_4_21 PTL_M1
Xclk_row_2__spl_4_t21 clk_row_2__spl_4_21 clk_row_2__spl_4_22 PTL_M1
Xclk_row_2__spl_4_t22 clk_row_2__spl_4_22 clk_row_2__spl_4_23 PTL_M1
Xclk_row_2__spl_4_t23 clk_row_2__spl_4_23 clk_row_2__spl_4_24 PTL_M1
Xclk_row_2__spl_4_t24 clk_row_2__spl_4_24 clk_row_2__spl_4_25 PTL_M1
Xclk_row_2__spl_4_t25 clk_row_2__spl_4_25 clk_row_2__spl_4_26 PTL_M1
Xclk_row_2__spl_4_t26 clk_row_2__spl_4_26 clk_row_2__spl_4_27 PTL_M1
Xclk_row_2__spl_4_t27 clk_row_2__spl_4_27 clk_row_2__spl_4_28 PTL_M1
Xclk_row_2__spl_4_t28 clk_row_2__spl_4_28 clk_row_2__spl_4_o PTLCAP_M1
Xcout_t0 cout_i cout_1 PTLCAP_M1
Xcout_t1 cout_1 cout_2 PTL_M1
Xcout_t2 cout_2 cout_3 PTL_M1
Xcout_t3 cout_3 cout_4 PTL_M1
Xcout_t4 cout_4 cout_5 PTL_M1
Xcout_t5 cout_5 cout_6 PTL_M1
Xcout_t6 cout_6 cout_7 PTL_M1
Xcout_t7 cout_7 cout_8 PTL_M1
Xcout_t8 cout_8 cout_9 BEND_PTL_M1
Xcout_t9 cout_9 cout_10 PTL_M1
Xcout_t10 cout_10 cout_11 PTL_M1
Xcout_t11 cout_11 cout_12 BEND_PTL_M1
Xcout_t12 cout_12 cout_13 PTL_M1
Xcout_t13 cout_13 cout_14 PTL_M1
Xcout_t14 cout_14 cout_15 PTL_M1
Xcout_t15 cout_15 cout_16 PTL_M1
Xcout_t16 cout_16 cout_17 PTL_M1
Xcout_t17 cout_17 cout_18 PTL_M1
Xcout_t18 cout_18 cout_19 PTL_M1
Xcout_t19 cout_19 cout_20 PTL_M1
Xcout_t20 cout_20 cout_21 PTL_M1
Xcout_t21 cout_21 cout_22 BEND_PTL_M1
Xcout_t22 cout_22 cout_o PTLCAP_M1
Xx1__spl_11__ff_7_t0 x1__spl_11__ff_7_i x1__spl_11__ff_7_1 PTLCAP_M1
Xx1__spl_11__ff_7_t1 x1__spl_11__ff_7_1 x1__spl_11__ff_7_2 PTL_M1
Xx1__spl_11__ff_7_t2 x1__spl_11__ff_7_2 x1__spl_11__ff_7_3 PTL_M1
Xx1__spl_11__ff_7_t3 x1__spl_11__ff_7_3 x1__spl_11__ff_7_4 PTL_M1
Xx1__spl_11__ff_7_t4 x1__spl_11__ff_7_4 x1__spl_11__ff_7_5 PTL_M1
Xx1__spl_11__ff_7_t5 x1__spl_11__ff_7_5 x1__spl_11__ff_7_6 BEND_PTL_M1
Xx1__spl_11__ff_7_t6 x1__spl_11__ff_7_6 x1__spl_11__ff_7_7 PTL_M1
Xx1__spl_11__ff_7_t7 x1__spl_11__ff_7_7 x1__spl_11__ff_7_8 PTL_M1
Xx1__spl_11__ff_7_t8 x1__spl_11__ff_7_8 x1__spl_11__ff_7_9 PTL_M1
Xx1__spl_11__ff_7_t9 x1__spl_11__ff_7_9 x1__spl_11__ff_7_10 PTL_M1
Xx1__spl_11__ff_7_t10 x1__spl_11__ff_7_10 x1__spl_11__ff_7_11 PTL_M1
Xx1__spl_11__ff_7_t11 x1__spl_11__ff_7_11 x1__spl_11__ff_7_12 BEND_PTL_M1
Xx1__spl_11__ff_7_t12 x1__spl_11__ff_7_12 x1__spl_11__ff_7_13 PTL_M1
Xx1__spl_11__ff_7_t13 x1__spl_11__ff_7_13 x1__spl_11__ff_7_14 PTL_M1
Xx1__spl_11__ff_7_t14 x1__spl_11__ff_7_14 x1__spl_11__ff_7_15 PTL_M1
Xx1__spl_11__ff_7_t15 x1__spl_11__ff_7_15 x1__spl_11__ff_7_16 PTL_M1
Xx1__spl_11__ff_7_t16 x1__spl_11__ff_7_16 x1__spl_11__ff_7_17 PTL_M1
Xx1__spl_11__ff_7_t17 x1__spl_11__ff_7_17 x1__spl_11__ff_7_18 PTL_M1
Xx1__spl_11__ff_7_t18 x1__spl_11__ff_7_18 x1__spl_11__ff_7_19 PTL_M1
Xx1__spl_11__ff_7_t19 x1__spl_11__ff_7_19 x1__spl_11__ff_7_20 PTL_M1
Xx1__spl_11__ff_7_t20 x1__spl_11__ff_7_20 x1__spl_11__ff_7_21 PTL_M1
Xx1__spl_11__ff_7_t21 x1__spl_11__ff_7_21 x1__spl_11__ff_7_22 PTL_M1
Xx1__spl_11__ff_7_t22 x1__spl_11__ff_7_22 x1__spl_11__ff_7_23 BEND_PTL_M1
Xx1__spl_11__ff_7_t23 x1__spl_11__ff_7_23 x1__spl_11__ff_7_24 PTL_M1
Xx1__spl_11__ff_7_t24 x1__spl_11__ff_7_24 x1__spl_11__ff_7_25 PTL_M1
Xx1__spl_11__ff_7_t25 x1__spl_11__ff_7_25 x1__spl_11__ff_7_26 PTL_M1
Xx1__spl_11__ff_7_t26 x1__spl_11__ff_7_26 x1__spl_11__ff_7_27 PTL_M1
Xx1__spl_11__ff_7_t27 x1__spl_11__ff_7_27 x1__spl_11__ff_7_28 PTL_M1
Xx1__spl_11__ff_7_t28 x1__spl_11__ff_7_28 x1__spl_11__ff_7_29 PTL_M1
Xx1__spl_11__ff_7_t29 x1__spl_11__ff_7_29 x1__spl_11__ff_7_30 PTL_M1
Xx1__spl_11__ff_7_t30 x1__spl_11__ff_7_30 x1__spl_11__ff_7_31 PTL_M1
Xx1__spl_11__ff_7_t31 x1__spl_11__ff_7_31 x1__spl_11__ff_7_32 PTL_M1
Xx1__spl_11__ff_7_t32 x1__spl_11__ff_7_32 x1__spl_11__ff_7_33 PTL_M1
Xx1__spl_11__ff_7_t33 x1__spl_11__ff_7_33 x1__spl_11__ff_7_34 PTL_M1
Xx1__spl_11__ff_7_t34 x1__spl_11__ff_7_34 x1__spl_11__ff_7_35 PTL_M1
Xx1__spl_11__ff_7_t35 x1__spl_11__ff_7_35 x1__spl_11__ff_7_36 PTL_M1
Xx1__spl_11__ff_7_t36 x1__spl_11__ff_7_36 x1__spl_11__ff_7_37 PTL_M1
Xx1__spl_11__ff_7_t37 x1__spl_11__ff_7_37 x1__spl_11__ff_7_38 PTL_M1
Xx1__spl_11__ff_7_t38 x1__spl_11__ff_7_38 x1__spl_11__ff_7_39 PTL_M1
Xx1__spl_11__ff_7_t39 x1__spl_11__ff_7_39 x1__spl_11__ff_7_40 PTL_M1
Xx1__spl_11__ff_7_t40 x1__spl_11__ff_7_40 x1__spl_11__ff_7_41 PTL_M1
Xx1__spl_11__ff_7_t41 x1__spl_11__ff_7_41 x1__spl_11__ff_7_42 PTL_M1
Xx1__spl_11__ff_7_t42 x1__spl_11__ff_7_42 x1__spl_11__ff_7_43 PTL_M1
Xx1__spl_11__ff_7_t43 x1__spl_11__ff_7_43 x1__spl_11__ff_7_44 BEND_PTL_M1
Xx1__spl_11__ff_7_t44 x1__spl_11__ff_7_44 x1__spl_11__ff_7_45 PTL_M1
Xx1__spl_11__ff_7_t45 x1__spl_11__ff_7_45 x1__spl_11__ff_7_46 PTL_M1
Xx1__spl_11__ff_7_t46 x1__spl_11__ff_7_46 x1__spl_11__ff_7_47 PTL_M1
Xx1__spl_11__ff_7_t47 x1__spl_11__ff_7_47 x1__spl_11__ff_7_48 PTL_M1
Xx1__spl_11__ff_7_t48 x1__spl_11__ff_7_48 x1__spl_11__ff_7_49 PTL_M1
Xx1__spl_11__ff_7_t49 x1__spl_11__ff_7_49 x1__spl_11__ff_7_50 PTL_M1
Xx1__spl_11__ff_7_t50 x1__spl_11__ff_7_50 x1__spl_11__ff_7_51 PTL_M1
Xx1__spl_11__ff_7_t51 x1__spl_11__ff_7_51 x1__spl_11__ff_7_52 PTL_M1
Xx1__spl_11__ff_7_t52 x1__spl_11__ff_7_52 x1__spl_11__ff_7_53 PTL_M1
Xx1__spl_11__ff_7_t53 x1__spl_11__ff_7_53 x1__spl_11__ff_7_o PTLCAP_M1
XTHmitll_XORT__clkbuf_5_t0 THmitll_XORT__clkbuf_5_i THmitll_XORT__clkbuf_5_1 PTLCAP_M1
XTHmitll_XORT__clkbuf_5_t1 THmitll_XORT__clkbuf_5_1 THmitll_XORT__clkbuf_5_2 PTL_M1
XTHmitll_XORT__clkbuf_5_t2 THmitll_XORT__clkbuf_5_2 THmitll_XORT__clkbuf_5_3 PTL_M1
XTHmitll_XORT__clkbuf_5_t3 THmitll_XORT__clkbuf_5_3 THmitll_XORT__clkbuf_5_4 BEND_PTL_M1
XTHmitll_XORT__clkbuf_5_t4 THmitll_XORT__clkbuf_5_4 THmitll_XORT__clkbuf_5_5 PTL_M1
XTHmitll_XORT__clkbuf_5_t5 THmitll_XORT__clkbuf_5_5 THmitll_XORT__clkbuf_5_6 PTL_M1
XTHmitll_XORT__clkbuf_5_t6 THmitll_XORT__clkbuf_5_6 THmitll_XORT__clkbuf_5_7 PTL_M1
XTHmitll_XORT__clkbuf_5_t7 THmitll_XORT__clkbuf_5_7 THmitll_XORT__clkbuf_5_8 PTL_M1
XTHmitll_XORT__clkbuf_5_t8 THmitll_XORT__clkbuf_5_8 THmitll_XORT__clkbuf_5_9 PTL_M1
XTHmitll_XORT__clkbuf_5_t9 THmitll_XORT__clkbuf_5_9 THmitll_XORT__clkbuf_5_10 PTL_M1
XTHmitll_XORT__clkbuf_5_t10 THmitll_XORT__clkbuf_5_10 THmitll_XORT__clkbuf_5_11 PTL_M1
XTHmitll_XORT__clkbuf_5_t11 THmitll_XORT__clkbuf_5_11 THmitll_XORT__clkbuf_5_12 PTL_M1
XTHmitll_XORT__clkbuf_5_t12 THmitll_XORT__clkbuf_5_12 THmitll_XORT__clkbuf_5_13 PTL_M1
XTHmitll_XORT__clkbuf_5_t13 THmitll_XORT__clkbuf_5_13 THmitll_XORT__clkbuf_5_14 PTL_M1
XTHmitll_XORT__clkbuf_5_t14 THmitll_XORT__clkbuf_5_14 THmitll_XORT__clkbuf_5_15 PTL_M1
XTHmitll_XORT__clkbuf_5_t15 THmitll_XORT__clkbuf_5_15 THmitll_XORT__clkbuf_5_16 PTL_M1
XTHmitll_XORT__clkbuf_5_t16 THmitll_XORT__clkbuf_5_16 THmitll_XORT__clkbuf_5_17 PTL_M1
XTHmitll_XORT__clkbuf_5_t17 THmitll_XORT__clkbuf_5_17 THmitll_XORT__clkbuf_5_18 PTL_M1
XTHmitll_XORT__clkbuf_5_t18 THmitll_XORT__clkbuf_5_18 THmitll_XORT__clkbuf_5_19 PTL_M1
XTHmitll_XORT__clkbuf_5_t19 THmitll_XORT__clkbuf_5_19 THmitll_XORT__clkbuf_5_20 BEND_PTL_M1
XTHmitll_XORT__clkbuf_5_t20 THmitll_XORT__clkbuf_5_20 THmitll_XORT__clkbuf_5_21 PTL_M1
XTHmitll_XORT__clkbuf_5_t21 THmitll_XORT__clkbuf_5_21 THmitll_XORT__clkbuf_5_22 PTL_M1
XTHmitll_XORT__clkbuf_5_t22 THmitll_XORT__clkbuf_5_22 THmitll_XORT__clkbuf_5_23 PTL_M1
XTHmitll_XORT__clkbuf_5_t23 THmitll_XORT__clkbuf_5_23 THmitll_XORT__clkbuf_5_24 PTL_M1
XTHmitll_XORT__clkbuf_5_t24 THmitll_XORT__clkbuf_5_24 THmitll_XORT__clkbuf_5_25 PTL_M1
XTHmitll_XORT__clkbuf_5_t25 THmitll_XORT__clkbuf_5_25 THmitll_XORT__clkbuf_5_26 PTL_M1
XTHmitll_XORT__clkbuf_5_t26 THmitll_XORT__clkbuf_5_26 THmitll_XORT__clkbuf_5_27 PTL_M1
XTHmitll_XORT__clkbuf_5_t27 THmitll_XORT__clkbuf_5_27 THmitll_XORT__clkbuf_5_28 PTL_M1
XTHmitll_XORT__clkbuf_5_t28 THmitll_XORT__clkbuf_5_28 THmitll_XORT__clkbuf_5_29 PTL_M1
XTHmitll_XORT__clkbuf_5_t29 THmitll_XORT__clkbuf_5_29 THmitll_XORT__clkbuf_5_30 PTL_M1
XTHmitll_XORT__clkbuf_5_t30 THmitll_XORT__clkbuf_5_30 THmitll_XORT__clkbuf_5_31 PTL_M1
XTHmitll_XORT__clkbuf_5_t31 THmitll_XORT__clkbuf_5_31 THmitll_XORT__clkbuf_5_32 PTL_M1
XTHmitll_XORT__clkbuf_5_t32 THmitll_XORT__clkbuf_5_32 THmitll_XORT__clkbuf_5_33 PTL_M1
XTHmitll_XORT__clkbuf_5_t33 THmitll_XORT__clkbuf_5_33 THmitll_XORT__clkbuf_5_34 PTL_M1
XTHmitll_XORT__clkbuf_5_t34 THmitll_XORT__clkbuf_5_34 THmitll_XORT__clkbuf_5_35 PTL_M1
XTHmitll_XORT__clkbuf_5_t35 THmitll_XORT__clkbuf_5_35 THmitll_XORT__clkbuf_5_36 PTL_M1
XTHmitll_XORT__clkbuf_5_t36 THmitll_XORT__clkbuf_5_36 THmitll_XORT__clkbuf_5_37 PTL_M1
XTHmitll_XORT__clkbuf_5_t37 THmitll_XORT__clkbuf_5_37 THmitll_XORT__clkbuf_5_38 BEND_PTL_M1
XTHmitll_XORT__clkbuf_5_t38 THmitll_XORT__clkbuf_5_38 THmitll_XORT__clkbuf_5_39 PTL_M1
XTHmitll_XORT__clkbuf_5_t39 THmitll_XORT__clkbuf_5_39 THmitll_XORT__clkbuf_5_40 PTL_M1
XTHmitll_XORT__clkbuf_5_t40 THmitll_XORT__clkbuf_5_40 THmitll_XORT__clkbuf_5_41 PTL_M1
XTHmitll_XORT__clkbuf_5_t41 THmitll_XORT__clkbuf_5_41 THmitll_XORT__clkbuf_5_42 PTL_M1
XTHmitll_XORT__clkbuf_5_t42 THmitll_XORT__clkbuf_5_42 THmitll_XORT__clkbuf_5_43 PTL_M1
XTHmitll_XORT__clkbuf_5_t43 THmitll_XORT__clkbuf_5_43 THmitll_XORT__clkbuf_5_44 BEND_PTL_M1
XTHmitll_XORT__clkbuf_5_t44 THmitll_XORT__clkbuf_5_44 THmitll_XORT__clkbuf_5_45 PTL_M1
XTHmitll_XORT__clkbuf_5_t45 THmitll_XORT__clkbuf_5_45 THmitll_XORT__clkbuf_5_46 PTL_M1
XTHmitll_XORT__clkbuf_5_t46 THmitll_XORT__clkbuf_5_46 THmitll_XORT__clkbuf_5_47 PTL_M1
XTHmitll_XORT__clkbuf_5_t47 THmitll_XORT__clkbuf_5_47 THmitll_XORT__clkbuf_5_48 PTL_M1
XTHmitll_XORT__clkbuf_5_t48 THmitll_XORT__clkbuf_5_48 THmitll_XORT__clkbuf_5_49 PTL_M1
XTHmitll_XORT__clkbuf_5_t49 THmitll_XORT__clkbuf_5_49 THmitll_XORT__clkbuf_5_50 BEND_PTL_M1
XTHmitll_XORT__clkbuf_5_t50 THmitll_XORT__clkbuf_5_50 THmitll_XORT__clkbuf_5_51 PTL_M1
XTHmitll_XORT__clkbuf_5_t51 THmitll_XORT__clkbuf_5_51 THmitll_XORT__clkbuf_5_o PTLCAP_M1
Xs1__out_entry_5_t0 s1__out_entry_5_i s1__out_entry_5_1 PTLCAP_M1
Xs1__out_entry_5_t1 s1__out_entry_5_1 s1__out_entry_5_2 BEND_PTL_M1
Xs1__out_entry_5_t2 s1__out_entry_5_2 s1__out_entry_5_3 PTL_M1
Xs1__out_entry_5_t3 s1__out_entry_5_3 s1__out_entry_5_4 PTL_M1
Xs1__out_entry_5_t4 s1__out_entry_5_4 s1__out_entry_5_5 PTL_M1
Xs1__out_entry_5_t5 s1__out_entry_5_5 s1__out_entry_5_6 PTL_M1
Xs1__out_entry_5_t6 s1__out_entry_5_6 s1__out_entry_5_7 PTL_M1
Xs1__out_entry_5_t7 s1__out_entry_5_7 s1__out_entry_5_8 PTL_M1
Xs1__out_entry_5_t8 s1__out_entry_5_8 s1__out_entry_5_9 PTL_M1
Xs1__out_entry_5_t9 s1__out_entry_5_9 s1__out_entry_5_10 PTL_M1
Xs1__out_entry_5_t10 s1__out_entry_5_10 s1__out_entry_5_11 PTL_M1
Xs1__out_entry_5_t11 s1__out_entry_5_11 s1__out_entry_5_12 PTL_M1
Xs1__out_entry_5_t12 s1__out_entry_5_12 s1__out_entry_5_13 PTL_M1
Xs1__out_entry_5_t13 s1__out_entry_5_13 s1__out_entry_5_14 BEND_PTL_M1
Xs1__out_entry_5_t14 s1__out_entry_5_14 s1__out_entry_5_15 PTL_M1
Xs1__out_entry_5_t15 s1__out_entry_5_15 s1__out_entry_5_16 PTL_M1
Xs1__out_entry_5_t16 s1__out_entry_5_16 s1__out_entry_5_17 PTL_M1
Xs1__out_entry_5_t17 s1__out_entry_5_17 s1__out_entry_5_18 PTL_M1
Xs1__out_entry_5_t18 s1__out_entry_5_18 s1__out_entry_5_19 PTL_M1
Xs1__out_entry_5_t19 s1__out_entry_5_19 s1__out_entry_5_20 PTL_M1
Xs1__out_entry_5_t20 s1__out_entry_5_20 s1__out_entry_5_21 PTL_M1
Xs1__out_entry_5_t21 s1__out_entry_5_21 s1__out_entry_5_22 PTL_M1
Xs1__out_entry_5_t22 s1__out_entry_5_22 s1__out_entry_5_23 PTL_M1
Xs1__out_entry_5_t23 s1__out_entry_5_23 s1__out_entry_5_24 PTL_M1
Xs1__out_entry_5_t24 s1__out_entry_5_24 s1__out_entry_5_25 PTL_M1
Xs1__out_entry_5_t25 s1__out_entry_5_25 s1__out_entry_5_26 PTL_M1
Xs1__out_entry_5_t26 s1__out_entry_5_26 s1__out_entry_5_27 PTL_M1
Xs1__out_entry_5_t27 s1__out_entry_5_27 s1__out_entry_5_28 PTL_M1
Xs1__out_entry_5_t28 s1__out_entry_5_28 s1__out_entry_5_29 PTL_M1
Xs1__out_entry_5_t29 s1__out_entry_5_29 s1__out_entry_5_30 PTL_M1
Xs1__out_entry_5_t30 s1__out_entry_5_30 s1__out_entry_5_31 PTL_M1
Xs1__out_entry_5_t31 s1__out_entry_5_31 s1__out_entry_5_32 PTL_M1
Xs1__out_entry_5_t32 s1__out_entry_5_32 s1__out_entry_5_33 PTL_M1
Xs1__out_entry_5_t33 s1__out_entry_5_33 s1__out_entry_5_34 PTL_M1
Xs1__out_entry_5_t34 s1__out_entry_5_34 s1__out_entry_5_35 PTL_M1
Xs1__out_entry_5_t35 s1__out_entry_5_35 s1__out_entry_5_36 PTL_M1
Xs1__out_entry_5_t36 s1__out_entry_5_36 s1__out_entry_5_37 PTL_M1
Xs1__out_entry_5_t37 s1__out_entry_5_37 s1__out_entry_5_38 BEND_PTL_M1
Xs1__out_entry_5_t38 s1__out_entry_5_38 s1__out_entry_5_39 PTL_M1
Xs1__out_entry_5_t39 s1__out_entry_5_39 s1__out_entry_5_40 PTL_M1
Xs1__out_entry_5_t40 s1__out_entry_5_40 s1__out_entry_5_41 PTL_M1
Xs1__out_entry_5_t41 s1__out_entry_5_41 s1__out_entry_5_42 PTL_M1
Xs1__out_entry_5_t42 s1__out_entry_5_42 s1__out_entry_5_43 PTL_M1
Xs1__out_entry_5_t43 s1__out_entry_5_43 s1__out_entry_5_44 PTL_M1
Xs1__out_entry_5_t44 s1__out_entry_5_44 s1__out_entry_5_45 PTL_M1
Xs1__out_entry_5_t45 s1__out_entry_5_45 s1__out_entry_5_46 PTL_M1
Xs1__out_entry_5_t46 s1__out_entry_5_46 s1__out_entry_5_47 PTL_M1
Xs1__out_entry_5_t47 s1__out_entry_5_47 s1__out_entry_5_48 BEND_PTL_M1
Xs1__out_entry_5_t48 s1__out_entry_5_48 s1__out_entry_5_49 PTL_M1
Xs1__out_entry_5_t49 s1__out_entry_5_49 s1__out_entry_5_50 PTL_M1
Xs1__out_entry_5_t50 s1__out_entry_5_50 s1__out_entry_5_51 PTL_M1
Xs1__out_entry_5_t51 s1__out_entry_5_51 s1__out_entry_5_o PTLCAP_M1
Xclk_row_3__spl_3_t0 clk_row_3__spl_3_i clk_row_3__spl_3_1 PTLCAP_M1
Xclk_row_3__spl_3_t1 clk_row_3__spl_3_1 clk_row_3__spl_3_2 BEND_PTL_M1
Xclk_row_3__spl_3_t2 clk_row_3__spl_3_2 clk_row_3__spl_3_3 PTL_M1
Xclk_row_3__spl_3_t3 clk_row_3__spl_3_3 clk_row_3__spl_3_4 PTL_M1
Xclk_row_3__spl_3_t4 clk_row_3__spl_3_4 clk_row_3__spl_3_5 PTL_M1
Xclk_row_3__spl_3_t5 clk_row_3__spl_3_5 clk_row_3__spl_3_6 BEND_PTL_M1
Xclk_row_3__spl_3_t6 clk_row_3__spl_3_6 clk_row_3__spl_3_7 PTL_M1
Xclk_row_3__spl_3_t7 clk_row_3__spl_3_7 clk_row_3__spl_3_8 PTL_M1
Xclk_row_3__spl_3_t8 clk_row_3__spl_3_8 clk_row_3__spl_3_9 PTL_M1
Xclk_row_3__spl_3_t9 clk_row_3__spl_3_9 clk_row_3__spl_3_10 PTL_M1
Xclk_row_3__spl_3_t10 clk_row_3__spl_3_10 clk_row_3__spl_3_11 PTL_M1
Xclk_row_3__spl_3_t11 clk_row_3__spl_3_11 clk_row_3__spl_3_12 PTL_M1
Xclk_row_3__spl_3_t12 clk_row_3__spl_3_12 clk_row_3__spl_3_13 PTL_M1
Xclk_row_3__spl_3_t13 clk_row_3__spl_3_13 clk_row_3__spl_3_14 PTL_M1
Xclk_row_3__spl_3_t14 clk_row_3__spl_3_14 clk_row_3__spl_3_15 PTL_M1
Xclk_row_3__spl_3_t15 clk_row_3__spl_3_15 clk_row_3__spl_3_16 PTL_M1
Xclk_row_3__spl_3_t16 clk_row_3__spl_3_16 clk_row_3__spl_3_17 BEND_PTL_M1
Xclk_row_3__spl_3_t17 clk_row_3__spl_3_17 clk_row_3__spl_3_18 PTL_M1
Xclk_row_3__spl_3_t18 clk_row_3__spl_3_18 clk_row_3__spl_3_19 PTL_M1
Xclk_row_3__spl_3_t19 clk_row_3__spl_3_19 clk_row_3__spl_3_20 BEND_PTL_M1
Xclk_row_3__spl_3_t20 clk_row_3__spl_3_20 clk_row_3__spl_3_21 PTL_M1
Xclk_row_3__spl_3_t21 clk_row_3__spl_3_21 clk_row_3__spl_3_22 PTL_M1
Xclk_row_3__spl_3_t22 clk_row_3__spl_3_22 clk_row_3__spl_3_23 PTL_M1
Xclk_row_3__spl_3_t23 clk_row_3__spl_3_23 clk_row_3__spl_3_24 PTL_M1
Xclk_row_3__spl_3_t24 clk_row_3__spl_3_24 clk_row_3__spl_3_25 PTL_M1
Xclk_row_3__spl_3_t25 clk_row_3__spl_3_25 clk_row_3__spl_3_26 BEND_PTL_M1
Xclk_row_3__spl_3_t26 clk_row_3__spl_3_26 clk_row_3__spl_3_27 PTL_M1
Xclk_row_3__spl_3_t27 clk_row_3__spl_3_27 clk_row_3__spl_3_28 PTL_M1
Xclk_row_3__spl_3_t28 clk_row_3__spl_3_28 clk_row_3__spl_3_29 PTL_M1
Xclk_row_3__spl_3_t29 clk_row_3__spl_3_29 clk_row_3__spl_3_30 PTL_M1
Xclk_row_3__spl_3_t30 clk_row_3__spl_3_30 clk_row_3__spl_3_31 PTL_M1
Xclk_row_3__spl_3_t31 clk_row_3__spl_3_31 clk_row_3__spl_3_32 PTL_M1
Xclk_row_3__spl_3_t32 clk_row_3__spl_3_32 clk_row_3__spl_3_33 PTL_M1
Xclk_row_3__spl_3_t33 clk_row_3__spl_3_33 clk_row_3__spl_3_34 PTL_M1
Xclk_row_3__spl_3_t34 clk_row_3__spl_3_34 clk_row_3__spl_3_35 PTL_M1
Xclk_row_3__spl_3_t35 clk_row_3__spl_3_35 clk_row_3__spl_3_36 PTL_M1
Xclk_row_3__spl_3_t36 clk_row_3__spl_3_36 clk_row_3__spl_3_37 PTL_M1
Xclk_row_3__spl_3_t37 clk_row_3__spl_3_37 clk_row_3__spl_3_38 PTL_M1
Xclk_row_3__spl_3_t38 clk_row_3__spl_3_38 clk_row_3__spl_3_39 PTL_M1
Xclk_row_3__spl_3_t39 clk_row_3__spl_3_39 clk_row_3__spl_3_40 PTL_M1
Xclk_row_3__spl_3_t40 clk_row_3__spl_3_40 clk_row_3__spl_3_41 BEND_PTL_M1
Xclk_row_3__spl_3_t41 clk_row_3__spl_3_41 clk_row_3__spl_3_o PTLCAP_M1
Xclk_spine_1_t0 clk_spine_1_i clk_spine_1_1 PTLCAP_M1
Xclk_spine_1_t1 clk_spine_1_1 clk_spine_1_2 PTL_M1
Xclk_spine_1_t2 clk_spine_1_2 clk_spine_1_3 PTL_M1
Xclk_spine_1_t3 clk_spine_1_3 clk_spine_1_4 PTL_M1
Xclk_spine_1_t4 clk_spine_1_4 clk_spine_1_5 PTL_M1
Xclk_spine_1_t5 clk_spine_1_5 clk_spine_1_6 PTL_M1
Xclk_spine_1_t6 clk_spine_1_6 clk_spine_1_7 PTL_M1
Xclk_spine_1_t7 clk_spine_1_7 clk_spine_1_8 PTL_M1
Xclk_spine_1_t8 clk_spine_1_8 clk_spine_1_9 PTL_M1
Xclk_spine_1_t9 clk_spine_1_9 clk_spine_1_10 PTL_M1
Xclk_spine_1_t10 clk_spine_1_10 clk_spine_1_11 PTL_M1
Xclk_spine_1_t11 clk_spine_1_11 clk_spine_1_12 PTL_M1
Xclk_spine_1_t12 clk_spine_1_12 clk_spine_1_13 PTL_M1
Xclk_spine_1_t13 clk_spine_1_13 clk_spine_1_14 PTL_M1
Xclk_spine_1_t14 clk_spine_1_14 clk_spine_1_15 PTL_M1
Xclk_spine_1_t15 clk_spine_1_15 clk_spine_1_16 PTL_M1
Xclk_spine_1_t16 clk_spine_1_16 clk_spine_1_17 PTL_M1
Xclk_spine_1_t17 clk_spine_1_17 clk_spine_1_18 BEND_PTL_M1
Xclk_spine_1_t18 clk_spine_1_18 clk_spine_1_19 PTL_M1
Xclk_spine_1_t19 clk_spine_1_19 clk_spine_1_20 PTL_M1
Xclk_spine_1_t20 clk_spine_1_20 clk_spine_1_21 BEND_PTL_M1
Xclk_spine_1_t21 clk_spine_1_21 clk_spine_1_22 PTL_M1
Xclk_spine_1_t22 clk_spine_1_22 clk_spine_1_23 PTL_M1
Xclk_spine_1_t23 clk_spine_1_23 clk_spine_1_24 BEND_PTL_M1
Xclk_spine_1_t24 clk_spine_1_24 clk_spine_1_o PTLCAP_M1
Xa1__spl_14_t0 a1__spl_14_i a1__spl_14_1 PTLCAP_M1
Xa1__spl_14_t1 a1__spl_14_1 a1__spl_14_2 BEND_PTL_M1
Xa1__spl_14_t2 a1__spl_14_2 a1__spl_14_3 PTL_M1
Xa1__spl_14_t3 a1__spl_14_3 a1__spl_14_4 PTL_M1
Xa1__spl_14_t4 a1__spl_14_4 a1__spl_14_5 PTL_M1
Xa1__spl_14_t5 a1__spl_14_5 a1__spl_14_6 PTL_M1
Xa1__spl_14_t6 a1__spl_14_6 a1__spl_14_7 PTL_M1
Xa1__spl_14_t7 a1__spl_14_7 a1__spl_14_8 PTL_M1
Xa1__spl_14_t8 a1__spl_14_8 a1__spl_14_9 PTL_M1
Xa1__spl_14_t9 a1__spl_14_9 a1__spl_14_10 PTL_M1
Xa1__spl_14_t10 a1__spl_14_10 a1__spl_14_11 PTL_M1
Xa1__spl_14_t11 a1__spl_14_11 a1__spl_14_12 BEND_PTL_M1
Xa1__spl_14_t12 a1__spl_14_12 a1__spl_14_13 PTL_M1
Xa1__spl_14_t13 a1__spl_14_13 a1__spl_14_14 PTL_M1
Xa1__spl_14_t14 a1__spl_14_14 a1__spl_14_15 PTL_M1
Xa1__spl_14_t15 a1__spl_14_15 a1__spl_14_16 PTL_M1
Xa1__spl_14_t16 a1__spl_14_16 a1__spl_14_17 PTL_M1
Xa1__spl_14_t17 a1__spl_14_17 a1__spl_14_18 PTL_M1
Xa1__spl_14_t18 a1__spl_14_18 a1__spl_14_19 PTL_M1
Xa1__spl_14_t19 a1__spl_14_19 a1__spl_14_20 PTL_M1
Xa1__spl_14_t20 a1__spl_14_20 a1__spl_14_21 PTL_M1
Xa1__spl_14_t21 a1__spl_14_21 a1__spl_14_22 PTL_M1
Xa1__spl_14_t22 a1__spl_14_22 a1__spl_14_23 PTL_M1
Xa1__spl_14_t23 a1__spl_14_23 a1__spl_14_24 PTL_M1
Xa1__spl_14_t24 a1__spl_14_24 a1__spl_14_25 PTL_M1
Xa1__spl_14_t25 a1__spl_14_25 a1__spl_14_26 PTL_M1
Xa1__spl_14_t26 a1__spl_14_26 a1__spl_14_27 PTL_M1
Xa1__spl_14_t27 a1__spl_14_27 a1__spl_14_o PTLCAP_M1
Xa1_t0 a1_i a1_1 PTLCAP_M1
Xa1_t1 a1_1 a1_2 PTL_M1
Xa1_t2 a1_2 a1_3 PTL_M1
Xa1_t3 a1_3 a1_4 BEND_PTL_M1
Xa1_t4 a1_4 a1_5 PTL_M1
Xa1_t5 a1_5 a1_6 PTL_M1
Xa1_t6 a1_6 a1_7 PTL_M1
Xa1_t7 a1_7 a1_8 PTL_M1
Xa1_t8 a1_8 a1_9 PTL_M1
Xa1_t9 a1_9 a1_10 PTL_M1
Xa1_t10 a1_10 a1_11 PTL_M1
Xa1_t11 a1_11 a1_12 PTL_M1
Xa1_t12 a1_12 a1_13 PTL_M1
Xa1_t13 a1_13 a1_14 BEND_PTL_M1
Xa1_t14 a1_14 a1_15 PTL_M1
Xa1_t15 a1_15 a1_16 PTL_M1
Xa1_t16 a1_16 a1_17 PTL_M1
Xa1_t17 a1_17 a1_18 PTL_M1
Xa1_t18 a1_18 a1_19 PTL_M1
Xa1_t19 a1_19 a1_20 PTL_M1
Xa1_t20 a1_20 a1_21 PTL_M1
Xa1_t21 a1_21 a1_22 PTL_M1
Xa1_t22 a1_22 a1_23 PTL_M1
Xa1_t23 a1_23 a1_24 PTL_M1
Xa1_t24 a1_24 a1_25 PTL_M1
Xa1_t25 a1_25 a1_26 PTL_M1
Xa1_t26 a1_26 a1_27 PTL_M1
Xa1_t27 a1_27 a1_28 PTL_M1
Xa1_t28 a1_28 a1_29 PTL_M1
Xa1_t29 a1_29 a1_30 PTL_M1
Xa1_t30 a1_30 a1_31 PTL_M1
Xa1_t31 a1_31 a1_32 PTL_M1
Xa1_t32 a1_32 a1_33 BEND_PTL_M1
Xa1_t33 a1_33 a1_o PTLCAP_M1
Xg1__ff_3_t0 g1__ff_3_i g1__ff_3_1 PTLCAP_M1
Xg1__ff_3_t1 g1__ff_3_1 g1__ff_3_2 PTL_M1
Xg1__ff_3_t2 g1__ff_3_2 g1__ff_3_3 PTL_M1
Xg1__ff_3_t3 g1__ff_3_3 g1__ff_3_4 PTL_M1
Xg1__ff_3_t4 g1__ff_3_4 g1__ff_3_5 PTL_M1
Xg1__ff_3_t5 g1__ff_3_5 g1__ff_3_6 BEND_PTL_M1
Xg1__ff_3_t6 g1__ff_3_6 g1__ff_3_7 PTL_M1
Xg1__ff_3_t7 g1__ff_3_7 g1__ff_3_8 PTL_M1
Xg1__ff_3_t8 g1__ff_3_8 g1__ff_3_9 PTL_M1
Xg1__ff_3_t9 g1__ff_3_9 g1__ff_3_10 PTL_M1
Xg1__ff_3_t10 g1__ff_3_10 g1__ff_3_11 PTL_M1
Xg1__ff_3_t11 g1__ff_3_11 g1__ff_3_12 PTL_M1
Xg1__ff_3_t12 g1__ff_3_12 g1__ff_3_13 BEND_PTL_M1
Xg1__ff_3_t13 g1__ff_3_13 g1__ff_3_14 PTL_M1
Xg1__ff_3_t14 g1__ff_3_14 g1__ff_3_15 PTL_M1
Xg1__ff_3_t15 g1__ff_3_15 g1__ff_3_16 PTL_M1
Xg1__ff_3_t16 g1__ff_3_16 g1__ff_3_17 PTL_M1
Xg1__ff_3_t17 g1__ff_3_17 g1__ff_3_18 PTL_M1
Xg1__ff_3_t18 g1__ff_3_18 g1__ff_3_19 PTL_M1
Xg1__ff_3_t19 g1__ff_3_19 g1__ff_3_20 PTL_M1
Xg1__ff_3_t20 g1__ff_3_20 g1__ff_3_21 PTL_M1
Xg1__ff_3_t21 g1__ff_3_21 g1__ff_3_22 PTL_M1
Xg1__ff_3_t22 g1__ff_3_22 g1__ff_3_23 PTL_M1
Xg1__ff_3_t23 g1__ff_3_23 g1__ff_3_24 PTL_M1
Xg1__ff_3_t24 g1__ff_3_24 g1__ff_3_25 PTL_M1
Xg1__ff_3_t25 g1__ff_3_25 g1__ff_3_26 PTL_M1
Xg1__ff_3_t26 g1__ff_3_26 g1__ff_3_o PTLCAP_M1
Xclk_spine_2_t0 clk_spine_2_i clk_spine_2_1 PTLCAP_M1
Xclk_spine_2_t1 clk_spine_2_1 clk_spine_2_2 PTL_M1
Xclk_spine_2_t2 clk_spine_2_2 clk_spine_2_3 BEND_PTL_M1
Xclk_spine_2_t3 clk_spine_2_3 clk_spine_2_4 PTL_M1
Xclk_spine_2_t4 clk_spine_2_4 clk_spine_2_5 PTL_M1
Xclk_spine_2_t5 clk_spine_2_5 clk_spine_2_6 PTL_M1
Xclk_spine_2_t6 clk_spine_2_6 clk_spine_2_7 PTL_M1
Xclk_spine_2_t7 clk_spine_2_7 clk_spine_2_8 PTL_M1
Xclk_spine_2_t8 clk_spine_2_8 clk_spine_2_9 PTL_M1
Xclk_spine_2_t9 clk_spine_2_9 clk_spine_2_10 PTL_M1
Xclk_spine_2_t10 clk_spine_2_10 clk_spine_2_11 PTL_M1
Xclk_spine_2_t11 clk_spine_2_11 clk_spine_2_12 PTL_M1
Xclk_spine_2_t12 clk_spine_2_12 clk_spine_2_13 PTL_M1
Xclk_spine_2_t13 clk_spine_2_13 clk_spine_2_14 PTL_M1
Xclk_spine_2_t14 clk_spine_2_14 clk_spine_2_15 PTL_M1
Xclk_spine_2_t15 clk_spine_2_15 clk_spine_2_16 PTL_M1
Xclk_spine_2_t16 clk_spine_2_16 clk_spine_2_17 PTL_M1
Xclk_spine_2_t17 clk_spine_2_17 clk_spine_2_18 PTL_M1
Xclk_spine_2_t18 clk_spine_2_18 clk_spine_2_19 PTL_M1
Xclk_spine_2_t19 clk_spine_2_19 clk_spine_2_20 PTL_M1
Xclk_spine_2_t20 clk_spine_2_20 clk_spine_2_21 PTL_M1
Xclk_spine_2_t21 clk_spine_2_21 clk_spine_2_22 PTL_M1
Xclk_spine_2_t22 clk_spine_2_22 clk_spine_2_23 PTL_M1
Xclk_spine_2_t23 clk_spine_2_23 clk_spine_2_24 PTL_M1
Xclk_spine_2_t24 clk_spine_2_24 clk_spine_2_25 BEND_PTL_M1
Xclk_spine_2_t25 clk_spine_2_25 clk_spine_2_26 PTL_M1
Xclk_spine_2_t26 clk_spine_2_26 clk_spine_2_o PTLCAP_M1
Xs0__out_ff_3_t0 s0__out_ff_3_i s0__out_ff_3_1 PTLCAP_M1
Xs0__out_ff_3_t1 s0__out_ff_3_1 s0__out_ff_3_2 PTL_M1
Xs0__out_ff_3_t2 s0__out_ff_3_2 s0__out_ff_3_3 BEND_PTL_M1
Xs0__out_ff_3_t3 s0__out_ff_3_3 s0__out_ff_3_4 PTL_M1
Xs0__out_ff_3_t4 s0__out_ff_3_4 s0__out_ff_3_5 PTL_M1
Xs0__out_ff_3_t5 s0__out_ff_3_5 s0__out_ff_3_6 PTL_M1
Xs0__out_ff_3_t6 s0__out_ff_3_6 s0__out_ff_3_7 PTL_M1
Xs0__out_ff_3_t7 s0__out_ff_3_7 s0__out_ff_3_8 PTL_M1
Xs0__out_ff_3_t8 s0__out_ff_3_8 s0__out_ff_3_9 PTL_M1
Xs0__out_ff_3_t9 s0__out_ff_3_9 s0__out_ff_3_10 PTL_M1
Xs0__out_ff_3_t10 s0__out_ff_3_10 s0__out_ff_3_11 PTL_M1
Xs0__out_ff_3_t11 s0__out_ff_3_11 s0__out_ff_3_12 PTL_M1
Xs0__out_ff_3_t12 s0__out_ff_3_12 s0__out_ff_3_13 PTL_M1
Xs0__out_ff_3_t13 s0__out_ff_3_13 s0__out_ff_3_14 PTL_M1
Xs0__out_ff_3_t14 s0__out_ff_3_14 s0__out_ff_3_15 PTL_M1
Xs0__out_ff_3_t15 s0__out_ff_3_15 s0__out_ff_3_16 PTL_M1
Xs0__out_ff_3_t16 s0__out_ff_3_16 s0__out_ff_3_17 PTL_M1
Xs0__out_ff_3_t17 s0__out_ff_3_17 s0__out_ff_3_18 PTL_M1
Xs0__out_ff_3_t18 s0__out_ff_3_18 s0__out_ff_3_19 PTL_M1
Xs0__out_ff_3_t19 s0__out_ff_3_19 s0__out_ff_3_20 PTL_M1
Xs0__out_ff_3_t20 s0__out_ff_3_20 s0__out_ff_3_21 PTL_M1
Xs0__out_ff_3_t21 s0__out_ff_3_21 s0__out_ff_3_22 PTL_M1
Xs0__out_ff_3_t22 s0__out_ff_3_22 s0__out_ff_3_23 PTL_M1
Xs0__out_ff_3_t23 s0__out_ff_3_23 s0__out_ff_3_24 PTL_M1
Xs0__out_ff_3_t24 s0__out_ff_3_24 s0__out_ff_3_25 PTL_M1
Xs0__out_ff_3_t25 s0__out_ff_3_25 s0__out_ff_3_26 PTL_M1
Xs0__out_ff_3_t26 s0__out_ff_3_26 s0__out_ff_3_27 BEND_PTL_M1
Xs0__out_ff_3_t27 s0__out_ff_3_27 s0__out_ff_3_28 BEND_PTL_M1
Xs0__out_ff_3_t28 s0__out_ff_3_28 s0__out_ff_3_o PTLCAP_M1
Xs0__out_ff_2_t0 s0__out_ff_2_i s0__out_ff_2_1 PTLCAP_M1
Xs0__out_ff_2_t1 s0__out_ff_2_1 s0__out_ff_2_2 PTL_M1
Xs0__out_ff_2_t2 s0__out_ff_2_2 s0__out_ff_2_3 PTL_M1
Xs0__out_ff_2_t3 s0__out_ff_2_3 s0__out_ff_2_4 PTL_M1
Xs0__out_ff_2_t4 s0__out_ff_2_4 s0__out_ff_2_5 PTL_M1
Xs0__out_ff_2_t5 s0__out_ff_2_5 s0__out_ff_2_6 BEND_PTL_M1
Xs0__out_ff_2_t6 s0__out_ff_2_6 s0__out_ff_2_7 PTL_M1
Xs0__out_ff_2_t7 s0__out_ff_2_7 s0__out_ff_2_8 PTL_M1
Xs0__out_ff_2_t8 s0__out_ff_2_8 s0__out_ff_2_9 BEND_PTL_M1
Xs0__out_ff_2_t9 s0__out_ff_2_9 s0__out_ff_2_10 PTL_M1
Xs0__out_ff_2_t10 s0__out_ff_2_10 s0__out_ff_2_11 PTL_M1
Xs0__out_ff_2_t11 s0__out_ff_2_11 s0__out_ff_2_12 PTL_M1
Xs0__out_ff_2_t12 s0__out_ff_2_12 s0__out_ff_2_13 PTL_M1
Xs0__out_ff_2_t13 s0__out_ff_2_13 s0__out_ff_2_14 PTL_M1
Xs0__out_ff_2_t14 s0__out_ff_2_14 s0__out_ff_2_15 PTL_M1
Xs0__out_ff_2_t15 s0__out_ff_2_15 s0__out_ff_2_16 PTL_M1
Xs0__out_ff_2_t16 s0__out_ff_2_16 s0__out_ff_2_17 PTL_M1
Xs0__out_ff_2_t17 s0__out_ff_2_17 s0__out_ff_2_18 PTL_M1
Xs0__out_ff_2_t18 s0__out_ff_2_18 s0__out_ff_2_19 PTL_M1
Xs0__out_ff_2_t19 s0__out_ff_2_19 s0__out_ff_2_20 PTL_M1
Xs0__out_ff_2_t20 s0__out_ff_2_20 s0__out_ff_2_21 PTL_M1
Xs0__out_ff_2_t21 s0__out_ff_2_21 s0__out_ff_2_22 PTL_M1
Xs0__out_ff_2_t22 s0__out_ff_2_22 s0__out_ff_2_23 PTL_M1
Xs0__out_ff_2_t23 s0__out_ff_2_23 s0__out_ff_2_24 PTL_M1
Xs0__out_ff_2_t24 s0__out_ff_2_24 s0__out_ff_2_25 PTL_M1
Xs0__out_ff_2_t25 s0__out_ff_2_25 s0__out_ff_2_26 PTL_M1
Xs0__out_ff_2_t26 s0__out_ff_2_26 s0__out_ff_2_27 PTL_M1
Xs0__out_ff_2_t27 s0__out_ff_2_27 s0__out_ff_2_28 PTL_M1
Xs0__out_ff_2_t28 s0__out_ff_2_28 s0__out_ff_2_29 PTL_M1
Xs0__out_ff_2_t29 s0__out_ff_2_29 s0__out_ff_2_30 BEND_PTL_M1
Xs0__out_ff_2_t30 s0__out_ff_2_30 s0__out_ff_2_31 PTL_M1
Xs0__out_ff_2_t31 s0__out_ff_2_31 s0__out_ff_2_o PTLCAP_M1
Xs0__out_entry_1_t0 s0__out_entry_1_i s0__out_entry_1_1 PTLCAP_M1
Xs0__out_entry_1_t1 s0__out_entry_1_1 s0__out_entry_1_2 BEND_PTL_M1
Xs0__out_entry_1_t2 s0__out_entry_1_2 s0__out_entry_1_3 PTL_M1
Xs0__out_entry_1_t3 s0__out_entry_1_3 s0__out_entry_1_4 PTL_M1
Xs0__out_entry_1_t4 s0__out_entry_1_4 s0__out_entry_1_5 PTL_M1
Xs0__out_entry_1_t5 s0__out_entry_1_5 s0__out_entry_1_6 BEND_PTL_M1
Xs0__out_entry_1_t6 s0__out_entry_1_6 s0__out_entry_1_7 PTL_M1
Xs0__out_entry_1_t7 s0__out_entry_1_7 s0__out_entry_1_8 PTL_M1
Xs0__out_entry_1_t8 s0__out_entry_1_8 s0__out_entry_1_9 PTL_M1
Xs0__out_entry_1_t9 s0__out_entry_1_9 s0__out_entry_1_10 PTL_M1
Xs0__out_entry_1_t10 s0__out_entry_1_10 s0__out_entry_1_11 PTL_M1
Xs0__out_entry_1_t11 s0__out_entry_1_11 s0__out_entry_1_12 PTL_M1
Xs0__out_entry_1_t12 s0__out_entry_1_12 s0__out_entry_1_13 PTL_M1
Xs0__out_entry_1_t13 s0__out_entry_1_13 s0__out_entry_1_14 PTL_M1
Xs0__out_entry_1_t14 s0__out_entry_1_14 s0__out_entry_1_15 PTL_M1
Xs0__out_entry_1_t15 s0__out_entry_1_15 s0__out_entry_1_16 PTL_M1
Xs0__out_entry_1_t16 s0__out_entry_1_16 s0__out_entry_1_17 PTL_M1
Xs0__out_entry_1_t17 s0__out_entry_1_17 s0__out_entry_1_18 PTL_M1
Xs0__out_entry_1_t18 s0__out_entry_1_18 s0__out_entry_1_19 PTL_M1
Xs0__out_entry_1_t19 s0__out_entry_1_19 s0__out_entry_1_20 PTL_M1
Xs0__out_entry_1_t20 s0__out_entry_1_20 s0__out_entry_1_21 PTL_M1
Xs0__out_entry_1_t21 s0__out_entry_1_21 s0__out_entry_1_22 PTL_M1
Xs0__out_entry_1_t22 s0__out_entry_1_22 s0__out_entry_1_23 PTL_M1
Xs0__out_entry_1_t23 s0__out_entry_1_23 s0__out_entry_1_24 BEND_PTL_M1
Xs0__out_entry_1_t24 s0__out_entry_1_24 s0__out_entry_1_25 PTL_M1
Xs0__out_entry_1_t25 s0__out_entry_1_25 s0__out_entry_1_26 PTL_M1
Xs0__out_entry_1_t26 s0__out_entry_1_26 s0__out_entry_1_27 PTL_M1
Xs0__out_entry_1_t27 s0__out_entry_1_27 s0__out_entry_1_28 BEND_PTL_M1
Xs0__out_entry_1_t28 s0__out_entry_1_28 s0__out_entry_1_29 PTL_M1
Xs0__out_entry_1_t29 s0__out_entry_1_29 s0__out_entry_1_30 PTL_M1
Xs0__out_entry_1_t30 s0__out_entry_1_30 s0__out_entry_1_31 PTL_M1
Xs0__out_entry_1_t31 s0__out_entry_1_31 s0__out_entry_1_32 PTL_M1
Xs0__out_entry_1_t32 s0__out_entry_1_32 s0__out_entry_1_33 PTL_M1
Xs0__out_entry_1_t33 s0__out_entry_1_33 s0__out_entry_1_34 PTL_M1
Xs0__out_entry_1_t34 s0__out_entry_1_34 s0__out_entry_1_35 PTL_M1
Xs0__out_entry_1_t35 s0__out_entry_1_35 s0__out_entry_1_36 PTL_M1
Xs0__out_entry_1_t36 s0__out_entry_1_36 s0__out_entry_1_37 BEND_PTL_M1
Xs0__out_entry_1_t37 s0__out_entry_1_37 s0__out_entry_1_38 PTL_M1
Xs0__out_entry_1_t38 s0__out_entry_1_38 s0__out_entry_1_39 PTL_M1
Xs0__out_entry_1_t39 s0__out_entry_1_39 s0__out_entry_1_40 BEND_PTL_M1
Xs0__out_entry_1_t40 s0__out_entry_1_40 s0__out_entry_1_41 PTL_M1
Xs0__out_entry_1_t41 s0__out_entry_1_41 s0__out_entry_1_o PTLCAP_M1
Xp1_t0 p1_i p1_1 PTLCAP_M1
Xp1_t1 p1_1 p1_2 PTL_M1
Xp1_t2 p1_2 p1_3 PTL_M1
Xp1_t3 p1_3 p1_4 PTL_M1
Xp1_t4 p1_4 p1_5 PTL_M1
Xp1_t5 p1_5 p1_6 BEND_PTL_M1
Xp1_t6 p1_6 p1_7 PTL_M1
Xp1_t7 p1_7 p1_8 PTL_M1
Xp1_t8 p1_8 p1_9 PTL_M1
Xp1_t9 p1_9 p1_10 PTL_M1
Xp1_t10 p1_10 p1_11 PTL_M1
Xp1_t11 p1_11 p1_12 PTL_M1
Xp1_t12 p1_12 p1_13 PTL_M1
Xp1_t13 p1_13 p1_14 PTL_M1
Xp1_t14 p1_14 p1_15 PTL_M1
Xp1_t15 p1_15 p1_16 PTL_M1
Xp1_t16 p1_16 p1_17 PTL_M1
Xp1_t17 p1_17 p1_18 PTL_M1
Xp1_t18 p1_18 p1_19 PTL_M1
Xp1_t19 p1_19 p1_20 PTL_M1
Xp1_t20 p1_20 p1_21 PTL_M1
Xp1_t21 p1_21 p1_22 PTL_M1
Xp1_t22 p1_22 p1_23 PTL_M1
Xp1_t23 p1_23 p1_24 PTL_M1
Xp1_t24 p1_24 p1_25 PTL_M1
Xp1_t25 p1_25 p1_26 PTL_M1
Xp1_t26 p1_26 p1_27 BEND_PTL_M1
Xp1_t27 p1_27 p1_o PTLCAP_M1
Xp0_t0 p0_i p0_1 PTLCAP_M1
Xp0_t1 p0_1 p0_2 BEND_PTL_M1
Xp0_t2 p0_2 p0_3 PTL_M1
Xp0_t3 p0_3 p0_4 PTL_M1
Xp0_t4 p0_4 p0_5 BEND_PTL_M1
Xp0_t5 p0_5 p0_6 BEND_PTL_M1
Xp0_t6 p0_6 p0_7 PTL_M1
Xp0_t7 p0_7 p0_8 PTL_M1
Xp0_t8 p0_8 p0_9 PTL_M1
Xp0_t9 p0_9 p0_10 PTL_M1
Xp0_t10 p0_10 p0_11 PTL_M1
Xp0_t11 p0_11 p0_12 PTL_M1
Xp0_t12 p0_12 p0_13 PTL_M1
Xp0_t13 p0_13 p0_14 PTL_M1
Xp0_t14 p0_14 p0_15 PTL_M1
Xp0_t15 p0_15 p0_16 PTL_M1
Xp0_t16 p0_16 p0_17 PTL_M1
Xp0_t17 p0_17 p0_18 PTL_M1
Xp0_t18 p0_18 p0_19 PTL_M1
Xp0_t19 p0_19 p0_20 PTL_M1
Xp0_t20 p0_20 p0_21 BEND_PTL_M1
Xp0_t21 p0_21 p0_22 PTL_M1
Xp0_t22 p0_22 p0_23 BEND_PTL_M1
Xp0_t23 p0_23 p0_24 PTL_M1
Xp0_t24 p0_24 p0_25 PTL_M1
Xp0_t25 p0_25 p0_26 PTL_M1
Xp0_t26 p0_26 p0_27 PTL_M1
Xp0_t27 p0_27 p0_28 PTL_M1
Xp0_t28 p0_28 p0_29 PTL_M1
Xp0_t29 p0_29 p0_30 PTL_M1
Xp0_t30 p0_30 p0_31 BEND_PTL_M1
Xp0_t31 p0_31 p0_o PTLCAP_M1
Xg1__ff_2_t0 g1__ff_2_i g1__ff_2_1 PTLCAP_M1
Xg1__ff_2_t1 g1__ff_2_1 g1__ff_2_2 PTL_M1
Xg1__ff_2_t2 g1__ff_2_2 g1__ff_2_3 PTL_M1
Xg1__ff_2_t3 g1__ff_2_3 g1__ff_2_4 PTL_M1
Xg1__ff_2_t4 g1__ff_2_4 g1__ff_2_5 PTL_M1
Xg1__ff_2_t5 g1__ff_2_5 g1__ff_2_6 BEND_PTL_M1
Xg1__ff_2_t6 g1__ff_2_6 g1__ff_2_7 PTL_M1
Xg1__ff_2_t7 g1__ff_2_7 g1__ff_2_8 PTL_M1
Xg1__ff_2_t8 g1__ff_2_8 g1__ff_2_9 PTL_M1
Xg1__ff_2_t9 g1__ff_2_9 g1__ff_2_10 PTL_M1
Xg1__ff_2_t10 g1__ff_2_10 g1__ff_2_11 PTL_M1
Xg1__ff_2_t11 g1__ff_2_11 g1__ff_2_12 PTL_M1
Xg1__ff_2_t12 g1__ff_2_12 g1__ff_2_13 PTL_M1
Xg1__ff_2_t13 g1__ff_2_13 g1__ff_2_14 PTL_M1
Xg1__ff_2_t14 g1__ff_2_14 g1__ff_2_15 PTL_M1
Xg1__ff_2_t15 g1__ff_2_15 g1__ff_2_16 BEND_PTL_M1
Xg1__ff_2_t16 g1__ff_2_16 g1__ff_2_17 PTL_M1
Xg1__ff_2_t17 g1__ff_2_17 g1__ff_2_18 PTL_M1
Xg1__ff_2_t18 g1__ff_2_18 g1__ff_2_19 PTL_M1
Xg1__ff_2_t19 g1__ff_2_19 g1__ff_2_20 PTL_M1
Xg1__ff_2_t20 g1__ff_2_20 g1__ff_2_21 PTL_M1
Xg1__ff_2_t21 g1__ff_2_21 g1__ff_2_22 PTL_M1
Xg1__ff_2_t22 g1__ff_2_22 g1__ff_2_23 PTL_M1
Xg1__ff_2_t23 g1__ff_2_23 g1__ff_2_24 PTL_M1
Xg1__ff_2_t24 g1__ff_2_24 g1__ff_2_25 PTL_M1
Xg1__ff_2_t25 g1__ff_2_25 g1__ff_2_26 PTL_M1
Xg1__ff_2_t26 g1__ff_2_26 g1__ff_2_27 PTL_M1
Xg1__ff_2_t27 g1__ff_2_27 g1__ff_2_28 PTL_M1
Xg1__ff_2_t28 g1__ff_2_28 g1__ff_2_29 PTL_M1
Xg1__ff_2_t29 g1__ff_2_29 g1__ff_2_30 BEND_PTL_M1
Xg1__ff_2_t30 g1__ff_2_30 g1__ff_2_31 PTL_M1
Xg1__ff_2_t31 g1__ff_2_31 g1__ff_2_32 PTL_M1
Xg1__ff_2_t32 g1__ff_2_32 g1__ff_2_33 PTL_M1
Xg1__ff_2_t33 g1__ff_2_33 g1__ff_2_34 PTL_M1
Xg1__ff_2_t34 g1__ff_2_34 g1__ff_2_35 PTL_M1
Xg1__ff_2_t35 g1__ff_2_35 g1__ff_2_36 PTL_M1
Xg1__ff_2_t36 g1__ff_2_36 g1__ff_2_37 PTL_M1
Xg1__ff_2_t37 g1__ff_2_37 g1__ff_2_38 PTL_M1
Xg1__ff_2_t38 g1__ff_2_38 g1__ff_2_39 PTL_M1
Xg1__ff_2_t39 g1__ff_2_39 g1__ff_2_40 PTL_M1
Xg1__ff_2_t40 g1__ff_2_40 g1__ff_2_41 BEND_PTL_M1
Xg1__ff_2_t41 g1__ff_2_41 g1__ff_2_42 PTL_M1
Xg1__ff_2_t42 g1__ff_2_42 g1__ff_2_43 PTL_M1
Xg1__ff_2_t43 g1__ff_2_43 g1__ff_2_44 PTL_M1
Xg1__ff_2_t44 g1__ff_2_44 g1__ff_2_45 PTL_M1
Xg1__ff_2_t45 g1__ff_2_45 g1__ff_2_46 PTL_M1
Xg1__ff_2_t46 g1__ff_2_46 g1__ff_2_47 PTL_M1
Xg1__ff_2_t47 g1__ff_2_47 g1__ff_2_48 PTL_M1
Xg1__ff_2_t48 g1__ff_2_48 g1__ff_2_49 PTL_M1
Xg1__ff_2_t49 g1__ff_2_49 g1__ff_2_50 BEND_PTL_M1
Xg1__ff_2_t50 g1__ff_2_50 g1__ff_2_51 PTL_M1
Xg1__ff_2_t51 g1__ff_2_51 g1__ff_2_52 PTL_M1
Xg1__ff_2_t52 g1__ff_2_52 g1__ff_2_53 BEND_PTL_M1
Xg1__ff_2_t53 g1__ff_2_53 g1__ff_2_54 PTL_M1
Xg1__ff_2_t54 g1__ff_2_54 g1__ff_2_o PTLCAP_M1
Xclk_spine_3_t0 clk_spine_3_i clk_spine_3_1 PTLCAP_M1
Xclk_spine_3_t1 clk_spine_3_1 clk_spine_3_2 BEND_PTL_M1
Xclk_spine_3_t2 clk_spine_3_2 clk_spine_3_3 PTL_M1
Xclk_spine_3_t3 clk_spine_3_3 clk_spine_3_4 PTL_M1
Xclk_spine_3_t4 clk_spine_3_4 clk_spine_3_5 PTL_M1
Xclk_spine_3_t5 clk_spine_3_5 clk_spine_3_6 BEND_PTL_M1
Xclk_spine_3_t6 clk_spine_3_6 clk_spine_3_7 PTL_M1
Xclk_spine_3_t7 clk_spine_3_7 clk_spine_3_8 PTL_M1
Xclk_spine_3_t8 clk_spine_3_8 clk_spine_3_9 PTL_M1
Xclk_spine_3_t9 clk_spine_3_9 clk_spine_3_10 PTL_M1
Xclk_spine_3_t10 clk_spine_3_10 clk_spine_3_11 PTL_M1
Xclk_spine_3_t11 clk_spine_3_11 clk_spine_3_12 PTL_M1
Xclk_spine_3_t12 clk_spine_3_12 clk_spine_3_13 PTL_M1
Xclk_spine_3_t13 clk_spine_3_13 clk_spine_3_14 PTL_M1
Xclk_spine_3_t14 clk_spine_3_14 clk_spine_3_15 PTL_M1
Xclk_spine_3_t15 clk_spine_3_15 clk_spine_3_16 PTL_M1
Xclk_spine_3_t16 clk_spine_3_16 clk_spine_3_17 PTL_M1
Xclk_spine_3_t17 clk_spine_3_17 clk_spine_3_18 PTL_M1
Xclk_spine_3_t18 clk_spine_3_18 clk_spine_3_19 PTL_M1
Xclk_spine_3_t19 clk_spine_3_19 clk_spine_3_20 PTL_M1
Xclk_spine_3_t20 clk_spine_3_20 clk_spine_3_21 PTL_M1
Xclk_spine_3_t21 clk_spine_3_21 clk_spine_3_22 PTL_M1
Xclk_spine_3_t22 clk_spine_3_22 clk_spine_3_23 PTL_M1
Xclk_spine_3_t23 clk_spine_3_23 clk_spine_3_24 PTL_M1
Xclk_spine_3_t24 clk_spine_3_24 clk_spine_3_25 PTL_M1
Xclk_spine_3_t25 clk_spine_3_25 clk_spine_3_26 PTL_M1
Xclk_spine_3_t26 clk_spine_3_26 clk_spine_3_27 PTL_M1
Xclk_spine_3_t27 clk_spine_3_27 clk_spine_3_28 PTL_M1
Xclk_spine_3_t28 clk_spine_3_28 clk_spine_3_29 PTL_M1
Xclk_spine_3_t29 clk_spine_3_29 clk_spine_3_30 PTL_M1
Xclk_spine_3_t30 clk_spine_3_30 clk_spine_3_31 BEND_PTL_M1
Xclk_spine_3_t31 clk_spine_3_31 clk_spine_3_32 PTL_M1
Xclk_spine_3_t32 clk_spine_3_32 clk_spine_3_33 PTL_M1
Xclk_spine_3_t33 clk_spine_3_33 clk_spine_3_34 PTL_M1
Xclk_spine_3_t34 clk_spine_3_34 clk_spine_3_35 PTL_M1
Xclk_spine_3_t35 clk_spine_3_35 clk_spine_3_36 PTL_M1
Xclk_spine_3_t36 clk_spine_3_36 clk_spine_3_37 PTL_M1
Xclk_spine_3_t37 clk_spine_3_37 clk_spine_3_38 PTL_M1
Xclk_spine_3_t38 clk_spine_3_38 clk_spine_3_o PTLCAP_M1
Xclk_row_1_t0 clk_row_1_i clk_row_1_1 PTLCAP_M1
Xclk_row_1_t1 clk_row_1_1 clk_row_1_2 PTL_M1
Xclk_row_1_t2 clk_row_1_2 clk_row_1_3 PTL_M1
Xclk_row_1_t3 clk_row_1_3 clk_row_1_4 PTL_M1
Xclk_row_1_t4 clk_row_1_4 clk_row_1_5 PTL_M1
Xclk_row_1_t5 clk_row_1_5 clk_row_1_6 PTL_M1
Xclk_row_1_t6 clk_row_1_6 clk_row_1_7 BEND_PTL_M1
Xclk_row_1_t7 clk_row_1_7 clk_row_1_8 PTL_M1
Xclk_row_1_t8 clk_row_1_8 clk_row_1_9 PTL_M1
Xclk_row_1_t9 clk_row_1_9 clk_row_1_10 PTL_M1
Xclk_row_1_t10 clk_row_1_10 clk_row_1_11 PTL_M1
Xclk_row_1_t11 clk_row_1_11 clk_row_1_12 PTL_M1
Xclk_row_1_t12 clk_row_1_12 clk_row_1_13 PTL_M1
Xclk_row_1_t13 clk_row_1_13 clk_row_1_14 PTL_M1
Xclk_row_1_t14 clk_row_1_14 clk_row_1_15 PTL_M1
Xclk_row_1_t15 clk_row_1_15 clk_row_1_16 PTL_M1
Xclk_row_1_t16 clk_row_1_16 clk_row_1_17 PTL_M1
Xclk_row_1_t17 clk_row_1_17 clk_row_1_18 PTL_M1
Xclk_row_1_t18 clk_row_1_18 clk_row_1_19 PTL_M1
Xclk_row_1_t19 clk_row_1_19 clk_row_1_20 PTL_M1
Xclk_row_1_t20 clk_row_1_20 clk_row_1_21 PTL_M1
Xclk_row_1_t21 clk_row_1_21 clk_row_1_22 BEND_PTL_M1
Xclk_row_1_t22 clk_row_1_22 clk_row_1_23 PTL_M1
Xclk_row_1_t23 clk_row_1_23 clk_row_1_24 PTL_M1
Xclk_row_1_t24 clk_row_1_24 clk_row_1_25 PTL_M1
Xclk_row_1_t25 clk_row_1_25 clk_row_1_26 PTL_M1
Xclk_row_1_t26 clk_row_1_26 clk_row_1_27 PTL_M1
Xclk_row_1_t27 clk_row_1_27 clk_row_1_28 PTL_M1
Xclk_row_1_t28 clk_row_1_28 clk_row_1_29 PTL_M1
Xclk_row_1_t29 clk_row_1_29 clk_row_1_o PTLCAP_M1
Xclk_row_4__spl_2_t0 clk_row_4__spl_2_i clk_row_4__spl_2_1 PTLCAP_M3
Xclk_row_4__spl_2_t1 clk_row_4__spl_2_1 clk_row_4__spl_2_2 PTL_M3
Xclk_row_4__spl_2_t2 clk_row_4__spl_2_2 clk_row_4__spl_2_3 PTL_M3
Xclk_row_4__spl_2_t3 clk_row_4__spl_2_3 clk_row_4__spl_2_4 PTL_M3
Xclk_row_4__spl_2_t4 clk_row_4__spl_2_4 clk_row_4__spl_2_5 PTL_M3
Xclk_row_4__spl_2_t5 clk_row_4__spl_2_5 clk_row_4__spl_2_6 PTL_M3
Xclk_row_4__spl_2_t6 clk_row_4__spl_2_6 clk_row_4__spl_2_7 PTL_M3
Xclk_row_4__spl_2_t7 clk_row_4__spl_2_7 clk_row_4__spl_2_8 PTL_M3
Xclk_row_4__spl_2_t8 clk_row_4__spl_2_8 clk_row_4__spl_2_9 PTL_M3
Xclk_row_4__spl_2_t9 clk_row_4__spl_2_9 clk_row_4__spl_2_10 PTL_M3
Xclk_row_4__spl_2_t10 clk_row_4__spl_2_10 clk_row_4__spl_2_11 PTL_M3
Xclk_row_4__spl_2_t11 clk_row_4__spl_2_11 clk_row_4__spl_2_12 PTL_M3
Xclk_row_4__spl_2_t12 clk_row_4__spl_2_12 clk_row_4__spl_2_13 PTL_M3
Xclk_row_4__spl_2_t13 clk_row_4__spl_2_13 clk_row_4__spl_2_14 PTL_M3
Xclk_row_4__spl_2_t14 clk_row_4__spl_2_14 clk_row_4__spl_2_15 PTL_M3
Xclk_row_4__spl_2_t15 clk_row_4__spl_2_15 clk_row_4__spl_2_16 PTL_M3
Xclk_row_4__spl_2_t16 clk_row_4__spl_2_16 clk_row_4__spl_2_17 PTL_M3
Xclk_row_4__spl_2_t17 clk_row_4__spl_2_17 clk_row_4__spl_2_18 PTL_M3
Xclk_row_4__spl_2_t18 clk_row_4__spl_2_18 clk_row_4__spl_2_19 PTL_M3
Xclk_row_4__spl_2_t19 clk_row_4__spl_2_19 clk_row_4__spl_2_20 PTL_M3
Xclk_row_4__spl_2_t20 clk_row_4__spl_2_20 clk_row_4__spl_2_21 PTL_M3
Xclk_row_4__spl_2_t21 clk_row_4__spl_2_21 clk_row_4__spl_2_22 BEND_PTL_M3
Xclk_row_4__spl_2_t22 clk_row_4__spl_2_22 clk_row_4__spl_2_23 PTL_M3
Xclk_row_4__spl_2_t23 clk_row_4__spl_2_23 clk_row_4__spl_2_24 PTL_M3
Xclk_row_4__spl_2_t24 clk_row_4__spl_2_24 clk_row_4__spl_2_25 PTL_M3
Xclk_row_4__spl_2_t25 clk_row_4__spl_2_25 clk_row_4__spl_2_26 PTL_M3
Xclk_row_4__spl_2_t26 clk_row_4__spl_2_26 clk_row_4__spl_2_27 PTL_M3
Xclk_row_4__spl_2_t27 clk_row_4__spl_2_27 clk_row_4__spl_2_28 PTL_M3
Xclk_row_4__spl_2_t28 clk_row_4__spl_2_28 clk_row_4__spl_2_29 PTL_M3
Xclk_row_4__spl_2_t29 clk_row_4__spl_2_29 clk_row_4__spl_2_30 PTL_M3
Xclk_row_4__spl_2_t30 clk_row_4__spl_2_30 clk_row_4__spl_2_o PTLCAP_M3
Xcin__spl_3__ff_10_t0 cin__spl_3__ff_10_i cin__spl_3__ff_10_1 PTLCAP_M1
Xcin__spl_3__ff_10_t1 cin__spl_3__ff_10_1 cin__spl_3__ff_10_2 BEND_PTL_M1
Xcin__spl_3__ff_10_t2 cin__spl_3__ff_10_2 cin__spl_3__ff_10_3 PTL_M1
Xcin__spl_3__ff_10_t3 cin__spl_3__ff_10_3 cin__spl_3__ff_10_4 PTL_M1
Xcin__spl_3__ff_10_t4 cin__spl_3__ff_10_4 cin__spl_3__ff_10_5 PTL_M1
Xcin__spl_3__ff_10_t5 cin__spl_3__ff_10_5 cin__spl_3__ff_10_6 PTL_M1
Xcin__spl_3__ff_10_t6 cin__spl_3__ff_10_6 cin__spl_3__ff_10_7 PTL_M1
Xcin__spl_3__ff_10_t7 cin__spl_3__ff_10_7 cin__spl_3__ff_10_8 PTL_M1
Xcin__spl_3__ff_10_t8 cin__spl_3__ff_10_8 cin__spl_3__ff_10_9 PTL_M1
Xcin__spl_3__ff_10_t9 cin__spl_3__ff_10_9 cin__spl_3__ff_10_10 PTL_M1
Xcin__spl_3__ff_10_t10 cin__spl_3__ff_10_10 cin__spl_3__ff_10_11 PTL_M1
Xcin__spl_3__ff_10_t11 cin__spl_3__ff_10_11 cin__spl_3__ff_10_12 PTL_M1
Xcin__spl_3__ff_10_t12 cin__spl_3__ff_10_12 cin__spl_3__ff_10_13 PTL_M1
Xcin__spl_3__ff_10_t13 cin__spl_3__ff_10_13 cin__spl_3__ff_10_14 PTL_M1
Xcin__spl_3__ff_10_t14 cin__spl_3__ff_10_14 cin__spl_3__ff_10_15 PTL_M1
Xcin__spl_3__ff_10_t15 cin__spl_3__ff_10_15 cin__spl_3__ff_10_16 PTL_M1
Xcin__spl_3__ff_10_t16 cin__spl_3__ff_10_16 cin__spl_3__ff_10_17 PTL_M1
Xcin__spl_3__ff_10_t17 cin__spl_3__ff_10_17 cin__spl_3__ff_10_18 PTL_M1
Xcin__spl_3__ff_10_t18 cin__spl_3__ff_10_18 cin__spl_3__ff_10_19 PTL_M1
Xcin__spl_3__ff_10_t19 cin__spl_3__ff_10_19 cin__spl_3__ff_10_20 BEND_PTL_M1
Xcin__spl_3__ff_10_t20 cin__spl_3__ff_10_20 cin__spl_3__ff_10_21 PTL_M1
Xcin__spl_3__ff_10_t21 cin__spl_3__ff_10_21 cin__spl_3__ff_10_22 PTL_M1
Xcin__spl_3__ff_10_t22 cin__spl_3__ff_10_22 cin__spl_3__ff_10_23 PTL_M1
Xcin__spl_3__ff_10_t23 cin__spl_3__ff_10_23 cin__spl_3__ff_10_24 PTL_M1
Xcin__spl_3__ff_10_t24 cin__spl_3__ff_10_24 cin__spl_3__ff_10_25 PTL_M1
Xcin__spl_3__ff_10_t25 cin__spl_3__ff_10_25 cin__spl_3__ff_10_26 PTL_M1
Xcin__spl_3__ff_10_t26 cin__spl_3__ff_10_26 cin__spl_3__ff_10_27 PTL_M1
Xcin__spl_3__ff_10_t27 cin__spl_3__ff_10_27 cin__spl_3__ff_10_28 PTL_M1
Xcin__spl_3__ff_10_t28 cin__spl_3__ff_10_28 cin__spl_3__ff_10_29 PTL_M1
Xcin__spl_3__ff_10_t29 cin__spl_3__ff_10_29 cin__spl_3__ff_10_30 PTL_M1
Xcin__spl_3__ff_10_t30 cin__spl_3__ff_10_30 cin__spl_3__ff_10_31 PTL_M1
Xcin__spl_3__ff_10_t31 cin__spl_3__ff_10_31 cin__spl_3__ff_10_32 PTL_M1
Xcin__spl_3__ff_10_t32 cin__spl_3__ff_10_32 cin__spl_3__ff_10_33 BEND_PTL_M1
Xcin__spl_3__ff_10_t33 cin__spl_3__ff_10_33 cin__spl_3__ff_10_o PTLCAP_M1
Xclk_row_1__vbuf_0_t0 clk_row_1__vbuf_0_i clk_row_1__vbuf_0_1 PTLCAP_M1
Xclk_row_1__vbuf_0_t1 clk_row_1__vbuf_0_1 clk_row_1__vbuf_0_2 PTL_M1
Xclk_row_1__vbuf_0_t2 clk_row_1__vbuf_0_2 clk_row_1__vbuf_0_3 BEND_PTL_M1
Xclk_row_1__vbuf_0_t3 clk_row_1__vbuf_0_3 clk_row_1__vbuf_0_4 BEND_PTL_M1
Xclk_row_1__vbuf_0_t4 clk_row_1__vbuf_0_4 clk_row_1__vbuf_0_5 PTL_M1
Xclk_row_1__vbuf_0_t5 clk_row_1__vbuf_0_5 clk_row_1__vbuf_0_6 PTL_M1
Xclk_row_1__vbuf_0_t6 clk_row_1__vbuf_0_6 clk_row_1__vbuf_0_7 BEND_PTL_M1
Xclk_row_1__vbuf_0_t7 clk_row_1__vbuf_0_7 clk_row_1__vbuf_0_8 BEND_PTL_M1
Xclk_row_1__vbuf_0_t8 clk_row_1__vbuf_0_8 clk_row_1__vbuf_0_9 PTL_M1
Xclk_row_1__vbuf_0_t9 clk_row_1__vbuf_0_9 clk_row_1__vbuf_0_10 PTL_M1
Xclk_row_1__vbuf_0_t10 clk_row_1__vbuf_0_10 clk_row_1__vbuf_0_11 PTL_M1
Xclk_row_1__vbuf_0_t11 clk_row_1__vbuf_0_11 clk_row_1__vbuf_0_12 PTL_M1
Xclk_row_1__vbuf_0_t12 clk_row_1__vbuf_0_12 clk_row_1__vbuf_0_13 BEND_PTL_M1
Xclk_row_1__vbuf_0_t13 clk_row_1__vbuf_0_13 clk_row_1__vbuf_0_14 PTL_M1
Xclk_row_1__vbuf_0_t14 clk_row_1__vbuf_0_14 clk_row_1__vbuf_0_15 PTL_M1
Xclk_row_1__vbuf_0_t15 clk_row_1__vbuf_0_15 clk_row_1__vbuf_0_16 PTL_M1
Xclk_row_1__vbuf_0_t16 clk_row_1__vbuf_0_16 clk_row_1__vbuf_0_17 PTL_M1
Xclk_row_1__vbuf_0_t17 clk_row_1__vbuf_0_17 clk_row_1__vbuf_0_18 PTL_M1
Xclk_row_1__vbuf_0_t18 clk_row_1__vbuf_0_18 clk_row_1__vbuf_0_19 PTL_M1
Xclk_row_1__vbuf_0_t19 clk_row_1__vbuf_0_19 clk_row_1__vbuf_0_20 PTL_M1
Xclk_row_1__vbuf_0_t20 clk_row_1__vbuf_0_20 clk_row_1__vbuf_0_21 PTL_M1
Xclk_row_1__vbuf_0_t21 clk_row_1__vbuf_0_21 clk_row_1__vbuf_0_22 PTL_M1
Xclk_row_1__vbuf_0_t22 clk_row_1__vbuf_0_22 clk_row_1__vbuf_0_23 PTL_M1
Xclk_row_1__vbuf_0_t23 clk_row_1__vbuf_0_23 clk_row_1__vbuf_0_24 PTL_M1
Xclk_row_1__vbuf_0_t24 clk_row_1__vbuf_0_24 clk_row_1__vbuf_0_25 PTL_M1
Xclk_row_1__vbuf_0_t25 clk_row_1__vbuf_0_25 clk_row_1__vbuf_0_26 PTL_M1
Xclk_row_1__vbuf_0_t26 clk_row_1__vbuf_0_26 clk_row_1__vbuf_0_27 PTL_M1
Xclk_row_1__vbuf_0_t27 clk_row_1__vbuf_0_27 clk_row_1__vbuf_0_28 PTL_M1
Xclk_row_1__vbuf_0_t28 clk_row_1__vbuf_0_28 clk_row_1__vbuf_0_29 BEND_PTL_M1
Xclk_row_1__vbuf_0_t29 clk_row_1__vbuf_0_29 clk_row_1__vbuf_0_30 PTL_M1
Xclk_row_1__vbuf_0_t30 clk_row_1__vbuf_0_30 clk_row_1__vbuf_0_31 PTL_M1
Xclk_row_1__vbuf_0_t31 clk_row_1__vbuf_0_31 clk_row_1__vbuf_0_32 PTL_M1
Xclk_row_1__vbuf_0_t32 clk_row_1__vbuf_0_32 clk_row_1__vbuf_0_33 PTL_M1
Xclk_row_1__vbuf_0_t33 clk_row_1__vbuf_0_33 clk_row_1__vbuf_0_34 PTL_M1
Xclk_row_1__vbuf_0_t34 clk_row_1__vbuf_0_34 clk_row_1__vbuf_0_35 PTL_M1
Xclk_row_1__vbuf_0_t35 clk_row_1__vbuf_0_35 clk_row_1__vbuf_0_36 PTL_M1
Xclk_row_1__vbuf_0_t36 clk_row_1__vbuf_0_36 clk_row_1__vbuf_0_o PTLCAP_M1
Xx0__spl_1_t0 x0__spl_1_i x0__spl_1_1 PTLCAP_M3
Xx0__spl_1_t1 x0__spl_1_1 x0__spl_1_2 PTL_M3
Xx0__spl_1_t2 x0__spl_1_2 x0__spl_1_3 BEND_PTL_M3
Xx0__spl_1_t3 x0__spl_1_3 x0__spl_1_4 PTL_M3
Xx0__spl_1_t4 x0__spl_1_4 x0__spl_1_5 PTL_M3
Xx0__spl_1_t5 x0__spl_1_5 x0__spl_1_6 PTL_M3
Xx0__spl_1_t6 x0__spl_1_6 x0__spl_1_7 PTL_M3
Xx0__spl_1_t7 x0__spl_1_7 x0__spl_1_8 PTL_M3
Xx0__spl_1_t8 x0__spl_1_8 x0__spl_1_9 PTL_M3
Xx0__spl_1_t9 x0__spl_1_9 x0__spl_1_10 PTL_M3
Xx0__spl_1_t10 x0__spl_1_10 x0__spl_1_11 PTL_M3
Xx0__spl_1_t11 x0__spl_1_11 x0__spl_1_12 PTL_M3
Xx0__spl_1_t12 x0__spl_1_12 x0__spl_1_13 PTL_M3
Xx0__spl_1_t13 x0__spl_1_13 x0__spl_1_14 PTL_M3
Xx0__spl_1_t14 x0__spl_1_14 x0__spl_1_15 PTL_M3
Xx0__spl_1_t15 x0__spl_1_15 x0__spl_1_16 PTL_M3
Xx0__spl_1_t16 x0__spl_1_16 x0__spl_1_17 PTL_M3
Xx0__spl_1_t17 x0__spl_1_17 x0__spl_1_18 PTL_M3
Xx0__spl_1_t18 x0__spl_1_18 x0__spl_1_19 PTL_M3
Xx0__spl_1_t19 x0__spl_1_19 x0__spl_1_20 PTL_M3
Xx0__spl_1_t20 x0__spl_1_20 x0__spl_1_21 PTL_M3
Xx0__spl_1_t21 x0__spl_1_21 x0__spl_1_o PTLCAP_M3
Xclk_row_3__vbuf_2_t0 clk_row_3__vbuf_2_i clk_row_3__vbuf_2_1 PTLCAP_M3
Xclk_row_3__vbuf_2_t1 clk_row_3__vbuf_2_1 clk_row_3__vbuf_2_2 PTL_M3
Xclk_row_3__vbuf_2_t2 clk_row_3__vbuf_2_2 clk_row_3__vbuf_2_3 BEND_PTL_M3
Xclk_row_3__vbuf_2_t3 clk_row_3__vbuf_2_3 clk_row_3__vbuf_2_4 PTL_M3
Xclk_row_3__vbuf_2_t4 clk_row_3__vbuf_2_4 clk_row_3__vbuf_2_5 PTL_M3
Xclk_row_3__vbuf_2_t5 clk_row_3__vbuf_2_5 clk_row_3__vbuf_2_6 PTL_M3
Xclk_row_3__vbuf_2_t6 clk_row_3__vbuf_2_6 clk_row_3__vbuf_2_7 PTL_M3
Xclk_row_3__vbuf_2_t7 clk_row_3__vbuf_2_7 clk_row_3__vbuf_2_8 PTL_M3
Xclk_row_3__vbuf_2_t8 clk_row_3__vbuf_2_8 clk_row_3__vbuf_2_9 PTL_M3
Xclk_row_3__vbuf_2_t9 clk_row_3__vbuf_2_9 clk_row_3__vbuf_2_10 PTL_M3
Xclk_row_3__vbuf_2_t10 clk_row_3__vbuf_2_10 clk_row_3__vbuf_2_11 PTL_M3
Xclk_row_3__vbuf_2_t11 clk_row_3__vbuf_2_11 clk_row_3__vbuf_2_12 PTL_M3
Xclk_row_3__vbuf_2_t12 clk_row_3__vbuf_2_12 clk_row_3__vbuf_2_13 PTL_M3
Xclk_row_3__vbuf_2_t13 clk_row_3__vbuf_2_13 clk_row_3__vbuf_2_14 PTL_M3
Xclk_row_3__vbuf_2_t14 clk_row_3__vbuf_2_14 clk_row_3__vbuf_2_15 PTL_M3
Xclk_row_3__vbuf_2_t15 clk_row_3__vbuf_2_15 clk_row_3__vbuf_2_16 PTL_M3
Xclk_row_3__vbuf_2_t16 clk_row_3__vbuf_2_16 clk_row_3__vbuf_2_17 PTL_M3
Xclk_row_3__vbuf_2_t17 clk_row_3__vbuf_2_17 clk_row_3__vbuf_2_18 PTL_M3
Xclk_row_3__vbuf_2_t18 clk_row_3__vbuf_2_18 clk_row_3__vbuf_2_19 BEND_PTL_M3
Xclk_row_3__vbuf_2_t19 clk_row_3__vbuf_2_19 clk_row_3__vbuf_2_20 PTL_M3
Xclk_row_3__vbuf_2_t20 clk_row_3__vbuf_2_20 clk_row_3__vbuf_2_21 PTL_M3
Xclk_row_3__vbuf_2_t21 clk_row_3__vbuf_2_21 clk_row_3__vbuf_2_22 PTL_M3
Xclk_row_3__vbuf_2_t22 clk_row_3__vbuf_2_22 clk_row_3__vbuf_2_23 PTL_M3
Xclk_row_3__vbuf_2_t23 clk_row_3__vbuf_2_23 clk_row_3__vbuf_2_24 PTL_M3
Xclk_row_3__vbuf_2_t24 clk_row_3__vbuf_2_24 clk_row_3__vbuf_2_25 PTL_M3
Xclk_row_3__vbuf_2_t25 clk_row_3__vbuf_2_25 clk_row_3__vbuf_2_26 PTL_M3
Xclk_row_3__vbuf_2_t26 clk_row_3__vbuf_2_26 clk_row_3__vbuf_2_o PTLCAP_M3
Xclk_row_2__spl_3_t0 clk_row_2__spl_3_i clk_row_2__spl_3_1 PTLCAP_M3
Xclk_row_2__spl_3_t1 clk_row_2__spl_3_1 clk_row_2__spl_3_2 PTL_M3
Xclk_row_2__spl_3_t2 clk_row_2__spl_3_2 clk_row_2__spl_3_3 PTL_M3
Xclk_row_2__spl_3_t3 clk_row_2__spl_3_3 clk_row_2__spl_3_4 PTL_M3
Xclk_row_2__spl_3_t4 clk_row_2__spl_3_4 clk_row_2__spl_3_5 PTL_M3
Xclk_row_2__spl_3_t5 clk_row_2__spl_3_5 clk_row_2__spl_3_6 PTL_M3
Xclk_row_2__spl_3_t6 clk_row_2__spl_3_6 clk_row_2__spl_3_7 PTL_M3
Xclk_row_2__spl_3_t7 clk_row_2__spl_3_7 clk_row_2__spl_3_8 PTL_M3
Xclk_row_2__spl_3_t8 clk_row_2__spl_3_8 clk_row_2__spl_3_9 BEND_PTL_M3
Xclk_row_2__spl_3_t9 clk_row_2__spl_3_9 clk_row_2__spl_3_10 PTL_M3
Xclk_row_2__spl_3_t10 clk_row_2__spl_3_10 clk_row_2__spl_3_11 PTL_M3
Xclk_row_2__spl_3_t11 clk_row_2__spl_3_11 clk_row_2__spl_3_12 PTL_M3
Xclk_row_2__spl_3_t12 clk_row_2__spl_3_12 clk_row_2__spl_3_13 PTL_M3
Xclk_row_2__spl_3_t13 clk_row_2__spl_3_13 clk_row_2__spl_3_14 PTL_M3
Xclk_row_2__spl_3_t14 clk_row_2__spl_3_14 clk_row_2__spl_3_15 PTL_M3
Xclk_row_2__spl_3_t15 clk_row_2__spl_3_15 clk_row_2__spl_3_16 PTL_M3
Xclk_row_2__spl_3_t16 clk_row_2__spl_3_16 clk_row_2__spl_3_17 PTL_M3
Xclk_row_2__spl_3_t17 clk_row_2__spl_3_17 clk_row_2__spl_3_18 BEND_PTL_M3
Xclk_row_2__spl_3_t18 clk_row_2__spl_3_18 clk_row_2__spl_3_19 PTL_M3
Xclk_row_2__spl_3_t19 clk_row_2__spl_3_19 clk_row_2__spl_3_20 PTL_M3
Xclk_row_2__spl_3_t20 clk_row_2__spl_3_20 clk_row_2__spl_3_21 BEND_PTL_M3
Xclk_row_2__spl_3_t21 clk_row_2__spl_3_21 clk_row_2__spl_3_22 PTL_M3
Xclk_row_2__spl_3_t22 clk_row_2__spl_3_22 clk_row_2__spl_3_o PTLCAP_M3
Xclk_row_3__spl_2_t0 clk_row_3__spl_2_i clk_row_3__spl_2_1 PTLCAP_M3
Xclk_row_3__spl_2_t1 clk_row_3__spl_2_1 clk_row_3__spl_2_2 PTL_M3
Xclk_row_3__spl_2_t2 clk_row_3__spl_2_2 clk_row_3__spl_2_3 PTL_M3
Xclk_row_3__spl_2_t3 clk_row_3__spl_2_3 clk_row_3__spl_2_4 PTL_M3
Xclk_row_3__spl_2_t4 clk_row_3__spl_2_4 clk_row_3__spl_2_5 PTL_M3
Xclk_row_3__spl_2_t5 clk_row_3__spl_2_5 clk_row_3__spl_2_6 PTL_M3
Xclk_row_3__spl_2_t6 clk_row_3__spl_2_6 clk_row_3__spl_2_7 PTL_M3
Xclk_row_3__spl_2_t7 clk_row_3__spl_2_7 clk_row_3__spl_2_8 PTL_M3
Xclk_row_3__spl_2_t8 clk_row_3__spl_2_8 clk_row_3__spl_2_9 PTL_M3
Xclk_row_3__spl_2_t9 clk_row_3__spl_2_9 clk_row_3__spl_2_10 PTL_M3
Xclk_row_3__spl_2_t10 clk_row_3__spl_2_10 clk_row_3__spl_2_11 PTL_M3
Xclk_row_3__spl_2_t11 clk_row_3__spl_2_11 clk_row_3__spl_2_12 PTL_M3
Xclk_row_3__spl_2_t12 clk_row_3__spl_2_12 clk_row_3__spl_2_13 PTL_M3
Xclk_row_3__spl_2_t13 clk_row_3__spl_2_13 clk_row_3__spl_2_14 PTL_M3
Xclk_row_3__spl_2_t14 clk_row_3__spl_2_14 clk_row_3__spl_2_15 PTL_M3
Xclk_row_3__spl_2_t15 clk_row_3__spl_2_15 clk_row_3__spl_2_16 BEND_PTL_M3
Xclk_row_3__spl_2_t16 clk_row_3__spl_2_16 clk_row_3__spl_2_17 PTL_M3
Xclk_row_3__spl_2_t17 clk_row_3__spl_2_17 clk_row_3__spl_2_18 PTL_M3
Xclk_row_3__spl_2_t18 clk_row_3__spl_2_18 clk_row_3__spl_2_19 PTL_M3
Xclk_row_3__spl_2_t19 clk_row_3__spl_2_19 clk_row_3__spl_2_20 PTL_M3
Xclk_row_3__spl_2_t20 clk_row_3__spl_2_20 clk_row_3__spl_2_21 PTL_M3
Xclk_row_3__spl_2_t21 clk_row_3__spl_2_21 clk_row_3__spl_2_22 PTL_M3
Xclk_row_3__spl_2_t22 clk_row_3__spl_2_22 clk_row_3__spl_2_23 PTL_M3
Xclk_row_3__spl_2_t23 clk_row_3__spl_2_23 clk_row_3__spl_2_24 PTL_M3
Xclk_row_3__spl_2_t24 clk_row_3__spl_2_24 clk_row_3__spl_2_o PTLCAP_M3
Xs1_t0 s1_i s1_1 PTLCAP_M3
Xs1_t1 s1_1 s1_2 BEND_PTL_M3
Xs1_t2 s1_2 s1_3 PTL_M3
Xs1_t3 s1_3 s1_4 PTL_M3
Xs1_t4 s1_4 s1_5 PTL_M3
Xs1_t5 s1_5 s1_6 PTL_M3
Xs1_t6 s1_6 s1_7 PTL_M3
Xs1_t7 s1_7 s1_8 PTL_M3
Xs1_t8 s1_8 s1_9 PTL_M3
Xs1_t9 s1_9 s1_10 BEND_PTL_M3
Xs1_t10 s1_10 s1_11 PTL_M3
Xs1_t11 s1_11 s1_12 BEND_PTL_M3
Xs1_t12 s1_12 s1_13 PTL_M3
Xs1_t13 s1_13 s1_14 PTL_M3
Xs1_t14 s1_14 s1_15 PTL_M3
Xs1_t15 s1_15 s1_16 PTL_M3
Xs1_t16 s1_16 s1_17 PTL_M3
Xs1_t17 s1_17 s1_18 PTL_M3
Xs1_t18 s1_18 s1_19 PTL_M3
Xs1_t19 s1_19 s1_20 PTL_M3
Xs1_t20 s1_20 s1_21 PTL_M3
Xs1_t21 s1_21 s1_22 PTL_M3
Xs1_t22 s1_22 s1_23 PTL_M3
Xs1_t23 s1_23 s1_24 PTL_M3
Xs1_t24 s1_24 s1_25 PTL_M3
Xs1_t25 s1_25 s1_26 PTL_M3
Xs1_t26 s1_26 s1_27 PTL_M3
Xs1_t27 s1_27 s1_o PTLCAP_M3
Xx0__spl_2_t0 x0__spl_2_i x0__spl_2_1 PTLCAP_M3
Xx0__spl_2_t1 x0__spl_2_1 x0__spl_2_2 PTL_M3
Xx0__spl_2_t2 x0__spl_2_2 x0__spl_2_3 PTL_M3
Xx0__spl_2_t3 x0__spl_2_3 x0__spl_2_4 PTL_M3
Xx0__spl_2_t4 x0__spl_2_4 x0__spl_2_5 PTL_M3
Xx0__spl_2_t5 x0__spl_2_5 x0__spl_2_6 PTL_M3
Xx0__spl_2_t6 x0__spl_2_6 x0__spl_2_7 BEND_PTL_M3
Xx0__spl_2_t7 x0__spl_2_7 x0__spl_2_8 PTL_M3
Xx0__spl_2_t8 x0__spl_2_8 x0__spl_2_9 PTL_M3
Xx0__spl_2_t9 x0__spl_2_9 x0__spl_2_10 PTL_M3
Xx0__spl_2_t10 x0__spl_2_10 x0__spl_2_11 PTL_M3
Xx0__spl_2_t11 x0__spl_2_11 x0__spl_2_12 PTL_M3
Xx0__spl_2_t12 x0__spl_2_12 x0__spl_2_13 PTL_M3
Xx0__spl_2_t13 x0__spl_2_13 x0__spl_2_14 PTL_M3
Xx0__spl_2_t14 x0__spl_2_14 x0__spl_2_15 PTL_M3
Xx0__spl_2_t15 x0__spl_2_15 x0__spl_2_16 PTL_M3
Xx0__spl_2_t16 x0__spl_2_16 x0__spl_2_17 PTL_M3
Xx0__spl_2_t17 x0__spl_2_17 x0__spl_2_18 PTL_M3
Xx0__spl_2_t18 x0__spl_2_18 x0__spl_2_19 PTL_M3
Xx0__spl_2_t19 x0__spl_2_19 x0__spl_2_20 PTL_M3
Xx0__spl_2_t20 x0__spl_2_20 x0__spl_2_21 PTL_M3
Xx0__spl_2_t21 x0__spl_2_21 x0__spl_2_22 PTL_M3
Xx0__spl_2_t22 x0__spl_2_22 x0__spl_2_23 PTL_M3
Xx0__spl_2_t23 x0__spl_2_23 x0__spl_2_24 PTL_M3
Xx0__spl_2_t24 x0__spl_2_24 x0__spl_2_25 PTL_M3
Xx0__spl_2_t25 x0__spl_2_25 x0__spl_2_26 PTL_M3
Xx0__spl_2_t26 x0__spl_2_26 x0__spl_2_27 BEND_PTL_M3
Xx0__spl_2_t27 x0__spl_2_27 x0__spl_2_o PTLCAP_M3
Xclk_row_3__spl_5_t0 clk_row_3__spl_5_i clk_row_3__spl_5_1 PTLCAP_M3
Xclk_row_3__spl_5_t1 clk_row_3__spl_5_1 clk_row_3__spl_5_2 PTL_M3
Xclk_row_3__spl_5_t2 clk_row_3__spl_5_2 clk_row_3__spl_5_3 PTL_M3
Xclk_row_3__spl_5_t3 clk_row_3__spl_5_3 clk_row_3__spl_5_4 PTL_M3
Xclk_row_3__spl_5_t4 clk_row_3__spl_5_4 clk_row_3__spl_5_5 PTL_M3
Xclk_row_3__spl_5_t5 clk_row_3__spl_5_5 clk_row_3__spl_5_6 PTL_M3
Xclk_row_3__spl_5_t6 clk_row_3__spl_5_6 clk_row_3__spl_5_7 PTL_M3
Xclk_row_3__spl_5_t7 clk_row_3__spl_5_7 clk_row_3__spl_5_8 PTL_M3
Xclk_row_3__spl_5_t8 clk_row_3__spl_5_8 clk_row_3__spl_5_9 PTL_M3
Xclk_row_3__spl_5_t9 clk_row_3__spl_5_9 clk_row_3__spl_5_10 PTL_M3
Xclk_row_3__spl_5_t10 clk_row_3__spl_5_10 clk_row_3__spl_5_11 PTL_M3
Xclk_row_3__spl_5_t11 clk_row_3__spl_5_11 clk_row_3__spl_5_12 PTL_M3
Xclk_row_3__spl_5_t12 clk_row_3__spl_5_12 clk_row_3__spl_5_13 PTL_M3
Xclk_row_3__spl_5_t13 clk_row_3__spl_5_13 clk_row_3__spl_5_14 PTL_M3
Xclk_row_3__spl_5_t14 clk_row_3__spl_5_14 clk_row_3__spl_5_15 PTL_M3
Xclk_row_3__spl_5_t15 clk_row_3__spl_5_15 clk_row_3__spl_5_16 PTL_M3
Xclk_row_3__spl_5_t16 clk_row_3__spl_5_16 clk_row_3__spl_5_17 BEND_PTL_M3
Xclk_row_3__spl_5_t17 clk_row_3__spl_5_17 clk_row_3__spl_5_18 PTL_M3
Xclk_row_3__spl_5_t18 clk_row_3__spl_5_18 clk_row_3__spl_5_19 PTL_M3
Xclk_row_3__spl_5_t19 clk_row_3__spl_5_19 clk_row_3__spl_5_20 PTL_M3
Xclk_row_3__spl_5_t20 clk_row_3__spl_5_20 clk_row_3__spl_5_21 PTL_M3
Xclk_row_3__spl_5_t21 clk_row_3__spl_5_21 clk_row_3__spl_5_22 PTL_M3
Xclk_row_3__spl_5_t22 clk_row_3__spl_5_22 clk_row_3__spl_5_23 PTL_M3
Xclk_row_3__spl_5_t23 clk_row_3__spl_5_23 clk_row_3__spl_5_24 PTL_M3
Xclk_row_3__spl_5_t24 clk_row_3__spl_5_24 clk_row_3__spl_5_25 PTL_M3
Xclk_row_3__spl_5_t25 clk_row_3__spl_5_25 clk_row_3__spl_5_o PTLCAP_M3
Xb1__spl_16_t0 b1__spl_16_i b1__spl_16_1 PTLCAP_M3
Xb1__spl_16_t1 b1__spl_16_1 b1__spl_16_2 PTL_M3
Xb1__spl_16_t2 b1__spl_16_2 b1__spl_16_3 PTL_M3
Xb1__spl_16_t3 b1__spl_16_3 b1__spl_16_4 PTL_M3
Xb1__spl_16_t4 b1__spl_16_4 b1__spl_16_5 PTL_M3
Xb1__spl_16_t5 b1__spl_16_5 b1__spl_16_6 BEND_PTL_M3
Xb1__spl_16_t6 b1__spl_16_6 b1__spl_16_7 PTL_M3
Xb1__spl_16_t7 b1__spl_16_7 b1__spl_16_8 PTL_M3
Xb1__spl_16_t8 b1__spl_16_8 b1__spl_16_9 PTL_M3
Xb1__spl_16_t9 b1__spl_16_9 b1__spl_16_10 PTL_M3
Xb1__spl_16_t10 b1__spl_16_10 b1__spl_16_11 PTL_M3
Xb1__spl_16_t11 b1__spl_16_11 b1__spl_16_12 PTL_M3
Xb1__spl_16_t12 b1__spl_16_12 b1__spl_16_13 PTL_M3
Xb1__spl_16_t13 b1__spl_16_13 b1__spl_16_14 PTL_M3
Xb1__spl_16_t14 b1__spl_16_14 b1__spl_16_15 PTL_M3
Xb1__spl_16_t15 b1__spl_16_15 b1__spl_16_16 PTL_M3
Xb1__spl_16_t16 b1__spl_16_16 b1__spl_16_17 PTL_M3
Xb1__spl_16_t17 b1__spl_16_17 b1__spl_16_18 PTL_M3
Xb1__spl_16_t18 b1__spl_16_18 b1__spl_16_19 PTL_M3
Xb1__spl_16_t19 b1__spl_16_19 b1__spl_16_20 PTL_M3
Xb1__spl_16_t20 b1__spl_16_20 b1__spl_16_21 PTL_M3
Xb1__spl_16_t21 b1__spl_16_21 b1__spl_16_22 PTL_M3
Xb1__spl_16_t22 b1__spl_16_22 b1__spl_16_23 PTL_M3
Xb1__spl_16_t23 b1__spl_16_23 b1__spl_16_24 PTL_M3
Xb1__spl_16_t24 b1__spl_16_24 b1__spl_16_25 PTL_M3
Xb1__spl_16_t25 b1__spl_16_25 b1__spl_16_26 BEND_PTL_M3
Xb1__spl_16_t26 b1__spl_16_26 b1__spl_16_o PTLCAP_M3
Xs0_t0 s0_i s0_1 PTLCAP_M3
Xs0_t1 s0_1 s0_2 PTL_M3
Xs0_t2 s0_2 s0_3 BEND_PTL_M3
Xs0_t3 s0_3 s0_4 PTL_M3
Xs0_t4 s0_4 s0_5 PTL_M3
Xs0_t5 s0_5 s0_6 PTL_M3
Xs0_t6 s0_6 s0_7 PTL_M3
Xs0_t7 s0_7 s0_8 PTL_M3
Xs0_t8 s0_8 s0_9 PTL_M3
Xs0_t9 s0_9 s0_10 PTL_M3
Xs0_t10 s0_10 s0_11 PTL_M3
Xs0_t11 s0_11 s0_12 PTL_M3
Xs0_t12 s0_12 s0_13 PTL_M3
Xs0_t13 s0_13 s0_14 PTL_M3
Xs0_t14 s0_14 s0_15 PTL_M3
Xs0_t15 s0_15 s0_16 PTL_M3
Xs0_t16 s0_16 s0_17 PTL_M3
Xs0_t17 s0_17 s0_18 PTL_M3
Xs0_t18 s0_18 s0_19 PTL_M3
Xs0_t19 s0_19 s0_20 PTL_M3
Xs0_t20 s0_20 s0_21 PTL_M3
Xs0_t21 s0_21 s0_22 PTL_M3
Xs0_t22 s0_22 s0_23 PTL_M3
Xs0_t23 s0_23 s0_24 PTL_M3
Xs0_t24 s0_24 s0_25 PTL_M3
Xs0_t25 s0_25 s0_26 PTL_M3
Xs0_t26 s0_26 s0_o PTLCAP_M3
Xg0__ff_8_t0 g0__ff_8_i g0__ff_8_1 PTLCAP_M3
Xg0__ff_8_t1 g0__ff_8_1 g0__ff_8_2 PTL_M3
Xg0__ff_8_t2 g0__ff_8_2 g0__ff_8_3 PTL_M3
Xg0__ff_8_t3 g0__ff_8_3 g0__ff_8_4 PTL_M3
Xg0__ff_8_t4 g0__ff_8_4 g0__ff_8_5 PTL_M3
Xg0__ff_8_t5 g0__ff_8_5 g0__ff_8_6 BEND_PTL_M3
Xg0__ff_8_t6 g0__ff_8_6 g0__ff_8_7 PTL_M3
Xg0__ff_8_t7 g0__ff_8_7 g0__ff_8_8 PTL_M3
Xg0__ff_8_t8 g0__ff_8_8 g0__ff_8_9 BEND_PTL_M3
Xg0__ff_8_t9 g0__ff_8_9 g0__ff_8_10 PTL_M3
Xg0__ff_8_t10 g0__ff_8_10 g0__ff_8_11 PTL_M3
Xg0__ff_8_t11 g0__ff_8_11 g0__ff_8_12 PTL_M3
Xg0__ff_8_t12 g0__ff_8_12 g0__ff_8_13 PTL_M3
Xg0__ff_8_t13 g0__ff_8_13 g0__ff_8_14 PTL_M3
Xg0__ff_8_t14 g0__ff_8_14 g0__ff_8_15 PTL_M3
Xg0__ff_8_t15 g0__ff_8_15 g0__ff_8_16 PTL_M3
Xg0__ff_8_t16 g0__ff_8_16 g0__ff_8_17 PTL_M3
Xg0__ff_8_t17 g0__ff_8_17 g0__ff_8_18 PTL_M3
Xg0__ff_8_t18 g0__ff_8_18 g0__ff_8_19 PTL_M3
Xg0__ff_8_t19 g0__ff_8_19 g0__ff_8_20 PTL_M3
Xg0__ff_8_t20 g0__ff_8_20 g0__ff_8_21 PTL_M3
Xg0__ff_8_t21 g0__ff_8_21 g0__ff_8_22 PTL_M3
Xg0__ff_8_t22 g0__ff_8_22 g0__ff_8_23 PTL_M3
Xg0__ff_8_t23 g0__ff_8_23 g0__ff_8_24 PTL_M3
Xg0__ff_8_t24 g0__ff_8_24 g0__ff_8_25 PTL_M3
Xg0__ff_8_t25 g0__ff_8_25 g0__ff_8_26 PTL_M3
Xg0__ff_8_t26 g0__ff_8_26 g0__ff_8_27 PTL_M3
Xg0__ff_8_t27 g0__ff_8_27 g0__ff_8_o PTLCAP_M3
Xg1_t0 g1_i g1_1 PTLCAP_M3
Xg1_t1 g1_1 g1_2 BEND_PTL_M3
Xg1_t2 g1_2 g1_3 PTL_M3
Xg1_t3 g1_3 g1_4 PTL_M3
Xg1_t4 g1_4 g1_5 PTL_M3
Xg1_t5 g1_5 g1_6 PTL_M3
Xg1_t6 g1_6 g1_7 PTL_M3
Xg1_t7 g1_7 g1_8 PTL_M3
Xg1_t8 g1_8 g1_9 PTL_M3
Xg1_t9 g1_9 g1_10 PTL_M3
Xg1_t10 g1_10 g1_11 PTL_M3
Xg1_t11 g1_11 g1_12 PTL_M3
Xg1_t12 g1_12 g1_13 PTL_M3
Xg1_t13 g1_13 g1_14 PTL_M3
Xg1_t14 g1_14 g1_15 PTL_M3
Xg1_t15 g1_15 g1_16 PTL_M3
Xg1_t16 g1_16 g1_17 PTL_M3
Xg1_t17 g1_17 g1_18 PTL_M3
Xg1_t18 g1_18 g1_19 PTL_M3
Xg1_t19 g1_19 g1_20 PTL_M3
Xg1_t20 g1_20 g1_21 PTL_M3
Xg1_t21 g1_21 g1_22 PTL_M3
Xg1_t22 g1_22 g1_23 PTL_M3
Xg1_t23 g1_23 g1_24 PTL_M3
Xg1_t24 g1_24 g1_25 PTL_M3
Xg1_t25 g1_25 g1_26 PTL_M3
Xg1_t26 g1_26 g1_27 BEND_PTL_M3
Xg1_t27 g1_27 g1_28 PTL_M3
Xg1_t28 g1_28 g1_29 PTL_M3
Xg1_t29 g1_29 g1_30 BEND_PTL_M3
Xg1_t30 g1_30 g1_o PTLCAP_M3
Xg0_t0 g0_i g0_1 PTLCAP_M3
Xg0_t1 g0_1 g0_2 BEND_PTL_M3
Xg0_t2 g0_2 g0_3 PTL_M3
Xg0_t3 g0_3 g0_4 PTL_M3
Xg0_t4 g0_4 g0_5 PTL_M3
Xg0_t5 g0_5 g0_6 PTL_M3
Xg0_t6 g0_6 g0_7 PTL_M3
Xg0_t7 g0_7 g0_8 PTL_M3
Xg0_t8 g0_8 g0_9 PTL_M3
Xg0_t9 g0_9 g0_10 PTL_M3
Xg0_t10 g0_10 g0_11 PTL_M3
Xg0_t11 g0_11 g0_12 PTL_M3
Xg0_t12 g0_12 g0_13 PTL_M3
Xg0_t13 g0_13 g0_14 PTL_M3
Xg0_t14 g0_14 g0_15 PTL_M3
Xg0_t15 g0_15 g0_16 PTL_M3
Xg0_t16 g0_16 g0_17 PTL_M3
Xg0_t17 g0_17 g0_18 PTL_M3
Xg0_t18 g0_18 g0_19 PTL_M3
Xg0_t19 g0_19 g0_20 PTL_M3
Xg0_t20 g0_20 g0_21 PTL_M3
Xg0_t21 g0_21 g0_22 PTL_M3
Xg0_t22 g0_22 g0_23 PTL_M3
Xg0_t23 g0_23 g0_24 PTL_M3
Xg0_t24 g0_24 g0_25 PTL_M3
Xg0_t25 g0_25 g0_26 PTL_M3
Xg0_t26 g0_26 g0_27 PTL_M3
Xg0_t27 g0_27 g0_28 PTL_M3
Xg0_t28 g0_28 g0_29 PTL_M3
Xg0_t29 g0_29 g0_30 BEND_PTL_M3
Xg0_t30 g0_30 g0_31 PTL_M3
Xg0_t31 g0_31 g0_32 PTL_M3
Xg0_t32 g0_32 g0_33 BEND_PTL_M3
Xg0_t33 g0_33 g0_34 PTL_M3
Xg0_t34 g0_34 g0_o PTLCAP_M3
Xclk_row_3__spl_6_t0 clk_row_3__spl_6_i clk_row_3__spl_6_1 PTLCAP_M3
Xclk_row_3__spl_6_t1 clk_row_3__spl_6_1 clk_row_3__spl_6_2 PTL_M3
Xclk_row_3__spl_6_t2 clk_row_3__spl_6_2 clk_row_3__spl_6_3 PTL_M3
Xclk_row_3__spl_6_t3 clk_row_3__spl_6_3 clk_row_3__spl_6_4 PTL_M3
Xclk_row_3__spl_6_t4 clk_row_3__spl_6_4 clk_row_3__spl_6_5 PTL_M3
Xclk_row_3__spl_6_t5 clk_row_3__spl_6_5 clk_row_3__spl_6_6 PTL_M3
Xclk_row_3__spl_6_t6 clk_row_3__spl_6_6 clk_row_3__spl_6_7 PTL_M3
Xclk_row_3__spl_6_t7 clk_row_3__spl_6_7 clk_row_3__spl_6_8 PTL_M3
Xclk_row_3__spl_6_t8 clk_row_3__spl_6_8 clk_row_3__spl_6_9 PTL_M3
Xclk_row_3__spl_6_t9 clk_row_3__spl_6_9 clk_row_3__spl_6_10 PTL_M3
Xclk_row_3__spl_6_t10 clk_row_3__spl_6_10 clk_row_3__spl_6_11 PTL_M3
Xclk_row_3__spl_6_t11 clk_row_3__spl_6_11 clk_row_3__spl_6_12 PTL_M3
Xclk_row_3__spl_6_t12 clk_row_3__spl_6_12 clk_row_3__spl_6_13 PTL_M3
Xclk_row_3__spl_6_t13 clk_row_3__spl_6_13 clk_row_3__spl_6_14 BEND_PTL_M3
Xclk_row_3__spl_6_t14 clk_row_3__spl_6_14 clk_row_3__spl_6_15 PTL_M3
Xclk_row_3__spl_6_t15 clk_row_3__spl_6_15 clk_row_3__spl_6_16 PTL_M3
Xclk_row_3__spl_6_t16 clk_row_3__spl_6_16 clk_row_3__spl_6_17 PTL_M3
Xclk_row_3__spl_6_t17 clk_row_3__spl_6_17 clk_row_3__spl_6_18 PTL_M3
Xclk_row_3__spl_6_t18 clk_row_3__spl_6_18 clk_row_3__spl_6_19 PTL_M3
Xclk_row_3__spl_6_t19 clk_row_3__spl_6_19 clk_row_3__spl_6_20 PTL_M3
Xclk_row_3__spl_6_t20 clk_row_3__spl_6_20 clk_row_3__spl_6_21 PTL_M3
Xclk_row_3__spl_6_t21 clk_row_3__spl_6_21 clk_row_3__spl_6_22 PTL_M3
Xclk_row_3__spl_6_t22 clk_row_3__spl_6_22 clk_row_3__spl_6_23 PTL_M3
Xclk_row_3__spl_6_t23 clk_row_3__spl_6_23 clk_row_3__spl_6_24 PTL_M3
Xclk_row_3__spl_6_t24 clk_row_3__spl_6_24 clk_row_3__spl_6_25 PTL_M3
Xclk_row_3__spl_6_t25 clk_row_3__spl_6_25 clk_row_3__spl_6_26 PTL_M3
Xclk_row_3__spl_6_t26 clk_row_3__spl_6_26 clk_row_3__spl_6_27 PTL_M3
Xclk_row_3__spl_6_t27 clk_row_3__spl_6_27 clk_row_3__spl_6_28 PTL_M3
Xclk_row_3__spl_6_t28 clk_row_3__spl_6_28 clk_row_3__spl_6_29 BEND_PTL_M3
Xclk_row_3__spl_6_t29 clk_row_3__spl_6_29 clk_row_3__spl_6_o PTLCAP_M3
Xclk_row_4__spl_3_t0 clk_row_4__spl_3_i clk_row_4__spl_3_1 PTLCAP_M3
Xclk_row_4__spl_3_t1 clk_row_4__spl_3_1 clk_row_4__spl_3_2 PTL_M3
Xclk_row_4__spl_3_t2 clk_row_4__spl_3_2 clk_row_4__spl_3_3 PTL_M3
Xclk_row_4__spl_3_t3 clk_row_4__spl_3_3 clk_row_4__spl_3_4 PTL_M3
Xclk_row_4__spl_3_t4 clk_row_4__spl_3_4 clk_row_4__spl_3_5 PTL_M3
Xclk_row_4__spl_3_t5 clk_row_4__spl_3_5 clk_row_4__spl_3_6 PTL_M3
Xclk_row_4__spl_3_t6 clk_row_4__spl_3_6 clk_row_4__spl_3_7 BEND_PTL_M3
Xclk_row_4__spl_3_t7 clk_row_4__spl_3_7 clk_row_4__spl_3_8 PTL_M3
Xclk_row_4__spl_3_t8 clk_row_4__spl_3_8 clk_row_4__spl_3_9 PTL_M3
Xclk_row_4__spl_3_t9 clk_row_4__spl_3_9 clk_row_4__spl_3_10 PTL_M3
Xclk_row_4__spl_3_t10 clk_row_4__spl_3_10 clk_row_4__spl_3_11 PTL_M3
Xclk_row_4__spl_3_t11 clk_row_4__spl_3_11 clk_row_4__spl_3_12 PTL_M3
Xclk_row_4__spl_3_t12 clk_row_4__spl_3_12 clk_row_4__spl_3_13 PTL_M3
Xclk_row_4__spl_3_t13 clk_row_4__spl_3_13 clk_row_4__spl_3_14 PTL_M3
Xclk_row_4__spl_3_t14 clk_row_4__spl_3_14 clk_row_4__spl_3_15 PTL_M3
Xclk_row_4__spl_3_t15 clk_row_4__spl_3_15 clk_row_4__spl_3_16 PTL_M3
Xclk_row_4__spl_3_t16 clk_row_4__spl_3_16 clk_row_4__spl_3_17 PTL_M3
Xclk_row_4__spl_3_t17 clk_row_4__spl_3_17 clk_row_4__spl_3_18 PTL_M3
Xclk_row_4__spl_3_t18 clk_row_4__spl_3_18 clk_row_4__spl_3_19 PTL_M3
Xclk_row_4__spl_3_t19 clk_row_4__spl_3_19 clk_row_4__spl_3_20 PTL_M3
Xclk_row_4__spl_3_t20 clk_row_4__spl_3_20 clk_row_4__spl_3_21 PTL_M3
Xclk_row_4__spl_3_t21 clk_row_4__spl_3_21 clk_row_4__spl_3_22 PTL_M3
Xclk_row_4__spl_3_t22 clk_row_4__spl_3_22 clk_row_4__spl_3_23 PTL_M3
Xclk_row_4__spl_3_t23 clk_row_4__spl_3_23 clk_row_4__spl_3_24 PTL_M3
Xclk_row_4__spl_3_t24 clk_row_4__spl_3_24 clk_row_4__spl_3_25 PTL_M3
Xclk_row_4__spl_3_t25 clk_row_4__spl_3_25 clk_row_4__spl_3_26 PTL_M3
Xclk_row_4__spl_3_t26 clk_row_4__spl_3_26 clk_row_4__spl_3_27 PTL_M3
Xclk_row_4__spl_3_t27 clk_row_4__spl_3_27 clk_row_4__spl_3_28 BEND_PTL_M3
Xclk_row_4__spl_3_t28 clk_row_4__spl_3_28 clk_row_4__spl_3_29 PTL_M3
Xclk_row_4__spl_3_t29 clk_row_4__spl_3_29 clk_row_4__spl_3_o PTLCAP_M3
Xx1_t0 x1_i x1_1 PTLCAP_M3
Xx1_t1 x1_1 x1_2 PTL_M3
Xx1_t2 x1_2 x1_3 PTL_M3
Xx1_t3 x1_3 x1_4 PTL_M3
Xx1_t4 x1_4 x1_5 PTL_M3
Xx1_t5 x1_5 x1_6 PTL_M3
Xx1_t6 x1_6 x1_7 PTL_M3
Xx1_t7 x1_7 x1_8 PTL_M3
Xx1_t8 x1_8 x1_9 PTL_M3
Xx1_t9 x1_9 x1_10 PTL_M3
Xx1_t10 x1_10 x1_11 PTL_M3
Xx1_t11 x1_11 x1_12 PTL_M3
Xx1_t12 x1_12 x1_13 PTL_M3
Xx1_t13 x1_13 x1_14 PTL_M3
Xx1_t14 x1_14 x1_15 PTL_M3
Xx1_t15 x1_15 x1_16 PTL_M3
Xx1_t16 x1_16 x1_17 PTL_M3
Xx1_t17 x1_17 x1_18 PTL_M3
Xx1_t18 x1_18 x1_19 PTL_M3
Xx1_t19 x1_19 x1_20 PTL_M3
Xx1_t20 x1_20 x1_21 BEND_PTL_M3
Xx1_t21 x1_21 x1_22 PTL_M3
Xx1_t22 x1_22 x1_23 PTL_M3
Xx1_t23 x1_23 x1_24 PTL_M3
Xx1_t24 x1_24 x1_25 PTL_M3
Xx1_t25 x1_25 x1_26 BEND_PTL_M3
Xx1_t26 x1_26 x1_27 PTL_M3
Xx1_t27 x1_27 x1_28 PTL_M3
Xx1_t28 x1_28 x1_29 PTL_M3
Xx1_t29 x1_29 x1_o PTLCAP_M3
Xc1__spl_6_t0 c1__spl_6_i c1__spl_6_1 PTLCAP_M3
Xc1__spl_6_t1 c1__spl_6_1 c1__spl_6_2 PTL_M3
Xc1__spl_6_t2 c1__spl_6_2 c1__spl_6_3 BEND_PTL_M3
Xc1__spl_6_t3 c1__spl_6_3 c1__spl_6_4 PTL_M3
Xc1__spl_6_t4 c1__spl_6_4 c1__spl_6_5 PTL_M3
Xc1__spl_6_t5 c1__spl_6_5 c1__spl_6_6 PTL_M3
Xc1__spl_6_t6 c1__spl_6_6 c1__spl_6_7 PTL_M3
Xc1__spl_6_t7 c1__spl_6_7 c1__spl_6_8 PTL_M3
Xc1__spl_6_t8 c1__spl_6_8 c1__spl_6_9 PTL_M3
Xc1__spl_6_t9 c1__spl_6_9 c1__spl_6_10 PTL_M3
Xc1__spl_6_t10 c1__spl_6_10 c1__spl_6_11 PTL_M3
Xc1__spl_6_t11 c1__spl_6_11 c1__spl_6_12 PTL_M3
Xc1__spl_6_t12 c1__spl_6_12 c1__spl_6_13 PTL_M3
Xc1__spl_6_t13 c1__spl_6_13 c1__spl_6_14 PTL_M3
Xc1__spl_6_t14 c1__spl_6_14 c1__spl_6_15 PTL_M3
Xc1__spl_6_t15 c1__spl_6_15 c1__spl_6_16 PTL_M3
Xc1__spl_6_t16 c1__spl_6_16 c1__spl_6_17 PTL_M3
Xc1__spl_6_t17 c1__spl_6_17 c1__spl_6_18 PTL_M3
Xc1__spl_6_t18 c1__spl_6_18 c1__spl_6_19 PTL_M3
Xc1__spl_6_t19 c1__spl_6_19 c1__spl_6_20 PTL_M3
Xc1__spl_6_t20 c1__spl_6_20 c1__spl_6_21 PTL_M3
Xc1__spl_6_t21 c1__spl_6_21 c1__spl_6_22 PTL_M3
Xc1__spl_6_t22 c1__spl_6_22 c1__spl_6_23 PTL_M3
Xc1__spl_6_t23 c1__spl_6_23 c1__spl_6_24 BEND_PTL_M3
Xc1__spl_6_t24 c1__spl_6_24 c1__spl_6_25 PTL_M3
Xc1__spl_6_t25 c1__spl_6_25 c1__spl_6_26 PTL_M3
Xc1__spl_6_t26 c1__spl_6_26 c1__spl_6_27 PTL_M3
Xc1__spl_6_t27 c1__spl_6_27 c1__spl_6_28 PTL_M3
Xc1__spl_6_t28 c1__spl_6_28 c1__spl_6_29 PTL_M3
Xc1__spl_6_t29 c1__spl_6_29 c1__spl_6_30 PTL_M3
Xc1__spl_6_t30 c1__spl_6_30 c1__spl_6_31 PTL_M3
Xc1__spl_6_t31 c1__spl_6_31 c1__spl_6_32 PTL_M3
Xc1__spl_6_t32 c1__spl_6_32 c1__spl_6_33 PTL_M3
Xc1__spl_6_t33 c1__spl_6_33 c1__spl_6_34 PTL_M3
Xc1__spl_6_t34 c1__spl_6_34 c1__spl_6_35 PTL_M3
Xc1__spl_6_t35 c1__spl_6_35 c1__spl_6_o PTLCAP_M3
Xg1__ff_1_t0 g1__ff_1_i g1__ff_1_1 PTLCAP_M3
Xg1__ff_1_t1 g1__ff_1_1 g1__ff_1_2 PTL_M3
Xg1__ff_1_t2 g1__ff_1_2 g1__ff_1_3 PTL_M3
Xg1__ff_1_t3 g1__ff_1_3 g1__ff_1_4 PTL_M3
Xg1__ff_1_t4 g1__ff_1_4 g1__ff_1_5 BEND_PTL_M3
Xg1__ff_1_t5 g1__ff_1_5 g1__ff_1_6 PTL_M3
Xg1__ff_1_t6 g1__ff_1_6 g1__ff_1_7 PTL_M3
Xg1__ff_1_t7 g1__ff_1_7 g1__ff_1_8 BEND_PTL_M3
Xg1__ff_1_t8 g1__ff_1_8 g1__ff_1_9 PTL_M3
Xg1__ff_1_t9 g1__ff_1_9 g1__ff_1_10 PTL_M3
Xg1__ff_1_t10 g1__ff_1_10 g1__ff_1_11 PTL_M3
Xg1__ff_1_t11 g1__ff_1_11 g1__ff_1_12 PTL_M3
Xg1__ff_1_t12 g1__ff_1_12 g1__ff_1_13 PTL_M3
Xg1__ff_1_t13 g1__ff_1_13 g1__ff_1_14 PTL_M3
Xg1__ff_1_t14 g1__ff_1_14 g1__ff_1_15 PTL_M3
Xg1__ff_1_t15 g1__ff_1_15 g1__ff_1_16 PTL_M3
Xg1__ff_1_t16 g1__ff_1_16 g1__ff_1_17 PTL_M3
Xg1__ff_1_t17 g1__ff_1_17 g1__ff_1_18 PTL_M3
Xg1__ff_1_t18 g1__ff_1_18 g1__ff_1_19 PTL_M3
Xg1__ff_1_t19 g1__ff_1_19 g1__ff_1_20 PTL_M3
Xg1__ff_1_t20 g1__ff_1_20 g1__ff_1_21 PTL_M3
Xg1__ff_1_t21 g1__ff_1_21 g1__ff_1_22 PTL_M3
Xg1__ff_1_t22 g1__ff_1_22 g1__ff_1_23 PTL_M3
Xg1__ff_1_t23 g1__ff_1_23 g1__ff_1_24 PTL_M3
Xg1__ff_1_t24 g1__ff_1_24 g1__ff_1_25 PTL_M3
Xg1__ff_1_t25 g1__ff_1_25 g1__ff_1_26 PTL_M3
Xg1__ff_1_t26 g1__ff_1_26 g1__ff_1_27 PTL_M3
Xg1__ff_1_t27 g1__ff_1_27 g1__ff_1_28 PTL_M3
Xg1__ff_1_t28 g1__ff_1_28 g1__ff_1_29 PTL_M3
Xg1__ff_1_t29 g1__ff_1_29 g1__ff_1_30 PTL_M3
Xg1__ff_1_t30 g1__ff_1_30 g1__ff_1_31 PTL_M3
Xg1__ff_1_t31 g1__ff_1_31 g1__ff_1_32 PTL_M3
Xg1__ff_1_t32 g1__ff_1_32 g1__ff_1_33 PTL_M3
Xg1__ff_1_t33 g1__ff_1_33 g1__ff_1_34 BEND_PTL_M3
Xg1__ff_1_t34 g1__ff_1_34 g1__ff_1_o PTLCAP_M3
Xclk_row_5_t0 clk_row_5_i clk_row_5_1 PTLCAP_M3
Xclk_row_5_t1 clk_row_5_1 clk_row_5_2 PTL_M3
Xclk_row_5_t2 clk_row_5_2 clk_row_5_3 PTL_M3
Xclk_row_5_t3 clk_row_5_3 clk_row_5_4 PTL_M3
Xclk_row_5_t4 clk_row_5_4 clk_row_5_5 PTL_M3
Xclk_row_5_t5 clk_row_5_5 clk_row_5_6 BEND_PTL_M3
Xclk_row_5_t6 clk_row_5_6 clk_row_5_7 PTL_M3
Xclk_row_5_t7 clk_row_5_7 clk_row_5_8 PTL_M3
Xclk_row_5_t8 clk_row_5_8 clk_row_5_9 PTL_M3
Xclk_row_5_t9 clk_row_5_9 clk_row_5_10 PTL_M3
Xclk_row_5_t10 clk_row_5_10 clk_row_5_11 PTL_M3
Xclk_row_5_t11 clk_row_5_11 clk_row_5_12 PTL_M3
Xclk_row_5_t12 clk_row_5_12 clk_row_5_13 PTL_M3
Xclk_row_5_t13 clk_row_5_13 clk_row_5_14 PTL_M3
Xclk_row_5_t14 clk_row_5_14 clk_row_5_15 PTL_M3
Xclk_row_5_t15 clk_row_5_15 clk_row_5_16 PTL_M3
Xclk_row_5_t16 clk_row_5_16 clk_row_5_17 PTL_M3
Xclk_row_5_t17 clk_row_5_17 clk_row_5_18 PTL_M3
Xclk_row_5_t18 clk_row_5_18 clk_row_5_19 PTL_M3
Xclk_row_5_t19 clk_row_5_19 clk_row_5_20 PTL_M3
Xclk_row_5_t20 clk_row_5_20 clk_row_5_21 PTL_M3
Xclk_row_5_t21 clk_row_5_21 clk_row_5_22 PTL_M3
Xclk_row_5_t22 clk_row_5_22 clk_row_5_23 PTL_M3
Xclk_row_5_t23 clk_row_5_23 clk_row_5_24 PTL_M3
Xclk_row_5_t24 clk_row_5_24 clk_row_5_25 PTL_M3
Xclk_row_5_t25 clk_row_5_25 clk_row_5_26 PTL_M3
Xclk_row_5_t26 clk_row_5_26 clk_row_5_27 PTL_M3
Xclk_row_5_t27 clk_row_5_27 clk_row_5_28 PTL_M3
Xclk_row_5_t28 clk_row_5_28 clk_row_5_29 PTL_M3
Xclk_row_5_t29 clk_row_5_29 clk_row_5_30 PTL_M3
Xclk_row_5_t30 clk_row_5_30 clk_row_5_31 PTL_M3
Xclk_row_5_t31 clk_row_5_31 clk_row_5_32 PTL_M3
Xclk_row_5_t32 clk_row_5_32 clk_row_5_33 BEND_PTL_M3
Xclk_row_5_t33 clk_row_5_33 clk_row_5_o PTLCAP_M3
Xcin__spl_4__ff_9_t0 cin__spl_4__ff_9_i cin__spl_4__ff_9_1 PTLCAP_M3
Xcin__spl_4__ff_9_t1 cin__spl_4__ff_9_1 cin__spl_4__ff_9_2 BEND_PTL_M3
Xcin__spl_4__ff_9_t2 cin__spl_4__ff_9_2 cin__spl_4__ff_9_3 PTL_M3
Xcin__spl_4__ff_9_t3 cin__spl_4__ff_9_3 cin__spl_4__ff_9_4 PTL_M3
Xcin__spl_4__ff_9_t4 cin__spl_4__ff_9_4 cin__spl_4__ff_9_5 PTL_M3
Xcin__spl_4__ff_9_t5 cin__spl_4__ff_9_5 cin__spl_4__ff_9_6 PTL_M3
Xcin__spl_4__ff_9_t6 cin__spl_4__ff_9_6 cin__spl_4__ff_9_7 PTL_M3
Xcin__spl_4__ff_9_t7 cin__spl_4__ff_9_7 cin__spl_4__ff_9_8 BEND_PTL_M3
Xcin__spl_4__ff_9_t8 cin__spl_4__ff_9_8 cin__spl_4__ff_9_9 PTL_M3
Xcin__spl_4__ff_9_t9 cin__spl_4__ff_9_9 cin__spl_4__ff_9_10 PTL_M3
Xcin__spl_4__ff_9_t10 cin__spl_4__ff_9_10 cin__spl_4__ff_9_11 PTL_M3
Xcin__spl_4__ff_9_t11 cin__spl_4__ff_9_11 cin__spl_4__ff_9_12 PTL_M3
Xcin__spl_4__ff_9_t12 cin__spl_4__ff_9_12 cin__spl_4__ff_9_13 PTL_M3
Xcin__spl_4__ff_9_t13 cin__spl_4__ff_9_13 cin__spl_4__ff_9_14 PTL_M3
Xcin__spl_4__ff_9_t14 cin__spl_4__ff_9_14 cin__spl_4__ff_9_15 PTL_M3
Xcin__spl_4__ff_9_t15 cin__spl_4__ff_9_15 cin__spl_4__ff_9_16 PTL_M3
Xcin__spl_4__ff_9_t16 cin__spl_4__ff_9_16 cin__spl_4__ff_9_17 PTL_M3
Xcin__spl_4__ff_9_t17 cin__spl_4__ff_9_17 cin__spl_4__ff_9_18 PTL_M3
Xcin__spl_4__ff_9_t18 cin__spl_4__ff_9_18 cin__spl_4__ff_9_19 PTL_M3
Xcin__spl_4__ff_9_t19 cin__spl_4__ff_9_19 cin__spl_4__ff_9_20 PTL_M3
Xcin__spl_4__ff_9_t20 cin__spl_4__ff_9_20 cin__spl_4__ff_9_21 PTL_M3
Xcin__spl_4__ff_9_t21 cin__spl_4__ff_9_21 cin__spl_4__ff_9_22 PTL_M3
Xcin__spl_4__ff_9_t22 cin__spl_4__ff_9_22 cin__spl_4__ff_9_23 PTL_M3
Xcin__spl_4__ff_9_t23 cin__spl_4__ff_9_23 cin__spl_4__ff_9_24 PTL_M3
Xcin__spl_4__ff_9_t24 cin__spl_4__ff_9_24 cin__spl_4__ff_9_25 PTL_M3
Xcin__spl_4__ff_9_t25 cin__spl_4__ff_9_25 cin__spl_4__ff_9_26 PTL_M3
Xcin__spl_4__ff_9_t26 cin__spl_4__ff_9_26 cin__spl_4__ff_9_27 PTL_M3
Xcin__spl_4__ff_9_t27 cin__spl_4__ff_9_27 cin__spl_4__ff_9_28 BEND_PTL_M3
Xcin__spl_4__ff_9_t28 cin__spl_4__ff_9_28 cin__spl_4__ff_9_29 PTL_M3
Xcin__spl_4__ff_9_t29 cin__spl_4__ff_9_29 cin__spl_4__ff_9_30 PTL_M3
Xcin__spl_4__ff_9_t30 cin__spl_4__ff_9_30 cin__spl_4__ff_9_31 BEND_PTL_M3
Xcin__spl_4__ff_9_t31 cin__spl_4__ff_9_31 cin__spl_4__ff_9_32 PTL_M3
Xcin__spl_4__ff_9_t32 cin__spl_4__ff_9_32 cin__spl_4__ff_9_33 PTL_M3
Xcin__spl_4__ff_9_t33 cin__spl_4__ff_9_33 cin__spl_4__ff_9_34 PTL_M3
Xcin__spl_4__ff_9_t34 cin__spl_4__ff_9_34 cin__spl_4__ff_9_35 PTL_M3
Xcin__spl_4__ff_9_t35 cin__spl_4__ff_9_35 cin__spl_4__ff_9_36 PTL_M3
Xcin__spl_4__ff_9_t36 cin__spl_4__ff_9_36 cin__spl_4__ff_9_37 BEND_PTL_M3
Xcin__spl_4__ff_9_t37 cin__spl_4__ff_9_37 cin__spl_4__ff_9_o PTLCAP_M3
Xclk_row_4_t0 clk_row_4_i clk_row_4_1 PTLCAP_M3
Xclk_row_4_t1 clk_row_4_1 clk_row_4_2 PTL_M3
Xclk_row_4_t2 clk_row_4_2 clk_row_4_3 PTL_M3
Xclk_row_4_t3 clk_row_4_3 clk_row_4_4 PTL_M3
Xclk_row_4_t4 clk_row_4_4 clk_row_4_5 PTL_M3
Xclk_row_4_t5 clk_row_4_5 clk_row_4_6 BEND_PTL_M3
Xclk_row_4_t6 clk_row_4_6 clk_row_4_7 PTL_M3
Xclk_row_4_t7 clk_row_4_7 clk_row_4_8 PTL_M3
Xclk_row_4_t8 clk_row_4_8 clk_row_4_9 PTL_M3
Xclk_row_4_t9 clk_row_4_9 clk_row_4_10 PTL_M3
Xclk_row_4_t10 clk_row_4_10 clk_row_4_11 PTL_M3
Xclk_row_4_t11 clk_row_4_11 clk_row_4_12 PTL_M3
Xclk_row_4_t12 clk_row_4_12 clk_row_4_13 PTL_M3
Xclk_row_4_t13 clk_row_4_13 clk_row_4_14 PTL_M3
Xclk_row_4_t14 clk_row_4_14 clk_row_4_15 PTL_M3
Xclk_row_4_t15 clk_row_4_15 clk_row_4_16 PTL_M3
Xclk_row_4_t16 clk_row_4_16 clk_row_4_17 PTL_M3
Xclk_row_4_t17 clk_row_4_17 clk_row_4_18 PTL_M3
Xclk_row_4_t18 clk_row_4_18 clk_row_4_19 PTL_M3
Xclk_row_4_t19 clk_row_4_19 clk_row_4_20 PTL_M3
Xclk_row_4_t20 clk_row_4_20 clk_row_4_21 PTL_M3
Xclk_row_4_t21 clk_row_4_21 clk_row_4_22 PTL_M3
Xclk_row_4_t22 clk_row_4_22 clk_row_4_23 PTL_M3
Xclk_row_4_t23 clk_row_4_23 clk_row_4_24 PTL_M3
Xclk_row_4_t24 clk_row_4_24 clk_row_4_25 PTL_M3
Xclk_row_4_t25 clk_row_4_25 clk_row_4_26 PTL_M3
Xclk_row_4_t26 clk_row_4_26 clk_row_4_27 PTL_M3
Xclk_row_4_t27 clk_row_4_27 clk_row_4_28 PTL_M3
Xclk_row_4_t28 clk_row_4_28 clk_row_4_29 PTL_M3
Xclk_row_4_t29 clk_row_4_29 clk_row_4_30 PTL_M3
Xclk_row_4_t30 clk_row_4_30 clk_row_4_31 PTL_M3
Xclk_row_4_t31 clk_row_4_31 clk_row_4_32 PTL_M3
Xclk_row_4_t32 clk_row_4_32 clk_row_4_33 BEND_PTL_M3
Xclk_row_4_t33 clk_row_4_33 clk_row_4_o PTLCAP_M3
Xcin_t0 cin_i cin_1 PTLCAP_M3
Xcin_t1 cin_1 cin_2 PTL_M3
Xcin_t2 cin_2 cin_3 PTL_M3
Xcin_t3 cin_3 cin_4 PTL_M3
Xcin_t4 cin_4 cin_5 PTL_M3
Xcin_t5 cin_5 cin_6 PTL_M3
Xcin_t6 cin_6 cin_7 PTL_M3
Xcin_t7 cin_7 cin_8 BEND_PTL_M3
Xcin_t8 cin_8 cin_9 PTL_M3
Xcin_t9 cin_9 cin_10 PTL_M3
Xcin_t10 cin_10 cin_11 PTL_M3
Xcin_t11 cin_11 cin_12 PTL_M3
Xcin_t12 cin_12 cin_13 PTL_M3
Xcin_t13 cin_13 cin_14 PTL_M3
Xcin_t14 cin_14 cin_15 PTL_M3
Xcin_t15 cin_15 cin_16 PTL_M3
Xcin_t16 cin_16 cin_17 PTL_M3
Xcin_t17 cin_17 cin_18 PTL_M3
Xcin_t18 cin_18 cin_19 PTL_M3
Xcin_t19 cin_19 cin_20 PTL_M3
Xcin_t20 cin_20 cin_21 PTL_M3
Xcin_t21 cin_21 cin_22 PTL_M3
Xcin_t22 cin_22 cin_23 PTL_M3
Xcin_t23 cin_23 cin_24 PTL_M3
Xcin_t24 cin_24 cin_25 PTL_M3
Xcin_t25 cin_25 cin_26 PTL_M3
Xcin_t26 cin_26 cin_27 PTL_M3
Xcin_t27 cin_27 cin_28 PTL_M3
Xcin_t28 cin_28 cin_29 PTL_M3
Xcin_t29 cin_29 cin_30 PTL_M3
Xcin_t30 cin_30 cin_31 PTL_M3
Xcin_t31 cin_31 cin_32 PTL_M3
Xcin_t32 cin_32 cin_33 PTL_M3
Xcin_t33 cin_33 cin_34 PTL_M3
Xcin_t34 cin_34 cin_35 PTL_M3
Xcin_t35 cin_35 cin_36 PTL_M3
Xcin_t36 cin_36 cin_37 PTL_M3
Xcin_t37 cin_37 cin_38 PTL_M3
Xcin_t38 cin_38 cin_39 PTL_M3
Xcin_t39 cin_39 cin_40 PTL_M3
Xcin_t40 cin_40 cin_41 BEND_PTL_M3
Xcin_t41 cin_41 cin_42 PTL_M3
Xcin_t42 cin_42 cin_43 PTL_M3
Xcin_t43 cin_43 cin_44 BEND_PTL_M3
Xcin_t44 cin_44 cin_o PTLCAP_M3
Xclk_row_2_t0 clk_row_2_i clk_row_2_1 PTLCAP_M1
Xclk_row_2_t1 clk_row_2_1 clk_row_2_2 PTL_M1
Xclk_row_2_t2 clk_row_2_2 clk_row_2_3 BEND_PTL_M1
Xclk_row_2_t3 clk_row_2_3 clk_row_2_4 PTL_M1
Xclk_row_2_t4 clk_row_2_4 clk_row_2_5 PTL_M1
Xclk_row_2_t5 clk_row_2_5 clk_row_2_6 PTL_M1
Xclk_row_2_t6 clk_row_2_6 clk_row_2_7 PTL_M1
Xclk_row_2_t7 clk_row_2_7 clk_row_2_8 PTL_M1
Xclk_row_2_t8 clk_row_2_8 clk_row_2_9 PTL_M1
Xclk_row_2_t9 clk_row_2_9 clk_row_2_10 PTL_M1
Xclk_row_2_t10 clk_row_2_10 clk_row_2_11 PTL_M1
Xclk_row_2_t11 clk_row_2_11 clk_row_2_12 PTL_M1
Xclk_row_2_t12 clk_row_2_12 clk_row_2_13 PTL_M1
Xclk_row_2_t13 clk_row_2_13 clk_row_2_14 PTL_M1
Xclk_row_2_t14 clk_row_2_14 clk_row_2_15 PTL_M1
Xclk_row_2_t15 clk_row_2_15 clk_row_2_16 PTL_M1
Xclk_row_2_t16 clk_row_2_16 clk_row_2_17 PTL_M1
Xclk_row_2_t17 clk_row_2_17 clk_row_2_18 PTL_M1
Xclk_row_2_t18 clk_row_2_18 clk_row_2_19 PTL_M1
Xclk_row_2_t19 clk_row_2_19 clk_row_2_20 PTL_M1
Xclk_row_2_t20 clk_row_2_20 clk_row_2_21 PTL_M1
Xclk_row_2_t21 clk_row_2_21 clk_row_2_22 VIA_M1_M3_STRAIGHT
Xclk_row_2_t22 clk_row_2_22 clk_row_2_23 PTL_M3
Xclk_row_2_t23 clk_row_2_23 clk_row_2_24 PTL_M3
Xclk_row_2_t24 clk_row_2_24 clk_row_2_25 PTL_M3
Xclk_row_2_t25 clk_row_2_25 clk_row_2_26 PTL_M3
Xclk_row_2_t26 clk_row_2_26 clk_row_2_27 PTL_M3
Xclk_row_2_t27 clk_row_2_27 clk_row_2_28 PTL_M3
Xclk_row_2_t28 clk_row_2_28 clk_row_2_29 PTL_M3
Xclk_row_2_t29 clk_row_2_29 clk_row_2_30 PTL_M3
Xclk_row_2_t30 clk_row_2_30 clk_row_2_31 PTL_M3
Xclk_row_2_t31 clk_row_2_31 clk_row_2_32 PTL_M3
Xclk_row_2_t32 clk_row_2_32 clk_row_2_33 PTL_M3
Xclk_row_2_t33 clk_row_2_33 clk_row_2_34 PTL_M3
Xclk_row_2_t34 clk_row_2_34 clk_row_2_35 PTL_M3
Xclk_row_2_t35 clk_row_2_35 clk_row_2_36 PTL_M3
Xclk_row_2_t36 clk_row_2_36 clk_row_2_37 PTL_M3
Xclk_row_2_t37 clk_row_2_37 clk_row_2_38 BEND_PTL_M3
Xclk_row_2_t38 clk_row_2_38 clk_row_2_39 PTL_M3
Xclk_row_2_t39 clk_row_2_39 clk_row_2_40 PTL_M3
Xclk_row_2_t40 clk_row_2_40 clk_row_2_41 PTL_M3
Xclk_row_2_t41 clk_row_2_41 clk_row_2_42 PTL_M3
Xclk_row_2_t42 clk_row_2_42 clk_row_2_43 PTL_M3
Xclk_row_2_t43 clk_row_2_43 clk_row_2_44 PTL_M3
Xclk_row_2_t44 clk_row_2_44 clk_row_2_45 PTL_M3
Xclk_row_2_t45 clk_row_2_45 clk_row_2_o PTLCAP_M3
XTHmitll_XORT_1 a0__spl_9_o b0__spl_7_o THmitll_XORT__clkbuf_7_o x0_i THmitll_XORT
XTHmitll_XORT_2 x0__spl_1_o cin__spl_3__ff_10_o THmitll_XORT__clkbuf_4_o s0__out_entry_1_i THmitll_XORT
XTHmitll_AND2T_3 a0__spl_10_o b0__spl_8_o THmitll_AND2T__clkbuf_6_o g0_i THmitll_AND2T
XTHmitll_AND2T_4 x0__spl_2_o cin__spl_4__ff_9_o THmitll_AND2T__clkbuf_3_o p0_i THmitll_AND2T
XTHmitll_OR2T_5 g0__ff_8_o p0_o clk_row_3__spl_6_o c1_i THmitll_OR2T
XTHmitll_XORT_6 a1__spl_13_o b1__spl_15_o THmitll_XORT__clkbuf_5_o x1_i THmitll_XORT
XTHmitll_XORT_7 x1__spl_11__ff_7_o c1__spl_5_o clk_row_4__spl_6_o s1__out_entry_5_i THmitll_XORT
XTHmitll_AND2T_8 a1__spl_14_o b1__spl_16_o clk_row_1__spl_4_o g1_i THmitll_AND2T
XTHmitll_AND2T_9 x1__spl_12__ff_5_o c1__spl_6_o clk_row_4__spl_5_o p1_i THmitll_AND2T
XTHmitll_OR2T_10 g1__ff_3_o p1_o THmitll_OR2T__clkbuf_1_o cout_i THmitll_OR2T
XTHmitll_SPLITT_11 x0_o x0__spl_2_i x0__spl_1_i THmitll_SPLITT
XTHmitll_SPLITT_12 cin__ff_1_o cin__spl_4__ff_9_i cin__spl_3__ff_10_i THmitll_SPLITT
XTHmitll_SPLITT_13 c1_o c1__spl_6_i c1__spl_5_i THmitll_SPLITT
XTHmitll_SPLITT_14 b0_o b0__spl_8_i b0__spl_7_i THmitll_SPLITT
XTHmitll_SPLITT_15 a0_o a0__spl_10_i a0__spl_9_i THmitll_SPLITT
XTHmitll_SPLITT_16 x1__ff_2__ff_3_o x1__spl_12__ff_5_i x1__spl_11__ff_7_i THmitll_SPLITT
XTHmitll_SPLITT_17 a1_o a1__spl_14_i a1__spl_13_i THmitll_SPLITT
XTHmitll_SPLITT_18 b1_o b1__spl_16_i b1__spl_15_i THmitll_SPLITT
XTHmitll_DFFT_19 g1_o THmitll_DFFT__clkbuf_2_o g1__ff_1_i THmitll_DFFT
XTHmitll_DFFT_20 g1__ff_1_o clk_row_3__spl_5_o g1__ff_2_i THmitll_DFFT
XTHmitll_DFFT_21 g1__ff_2_o clk_row_4__spl_3_o g1__ff_3_i THmitll_DFFT
XTHmitll_DFFT_22 g0_o clk_row_2__spl_4_o g0__ff_8_i THmitll_DFFT
XTHmitll_DFFT_23 cin_o clk_row_1__spl_3_o cin__ff_1_i THmitll_DFFT
XTHmitll_DFFT_24 x1_o clk_row_2__spl_3_o x1__ff_2_i THmitll_DFFT
XTHmitll_DFFT_25 x1__ff_2__vbuf_1_o clk_row_3__spl_3_o x1__ff_2__ff_3_i THmitll_DFFT
XTHmitll_DFFT_26 s0__out_entry_1_o clk_row_3__spl_2_o s0__out_ff_2_i THmitll_DFFT
XTHmitll_DFFT_27 s0__out_ff_2_o clk_row_4__spl_2_o s0__out_ff_3_i THmitll_DFFT
XTHmitll_DFFT_28 s0__out_ff_3_o clk_row_5__spl_3_o s0_i THmitll_DFFT
XTHmitll_DFFT_29 s1__out_entry_5_o clk_row_5__spl_2_o s1_i THmitll_DFFT
XTHmitll_SPLITT_1_0 clk_row_1__vbuf_0_o clk_row_1__spl_6_i clk_row_1__spl_1_i THmitll_SPLITT
XTHmitll_SPLITT_1_1 clk_row_1__spl_1_o clk_row_1__spl_5_i clk_row_1__spl_2_i THmitll_SPLITT
XTHmitll_SPLITT_1_2 clk_row_1__spl_2_o clk_row_1__spl_4_i clk_row_1__spl_3_i THmitll_SPLITT
XTHmitll_BUFFT_1_5 clk_row_1__spl_5_o THmitll_XORT__clkbuf_5_i THmitll_BUFFT
XTHmitll_SPLITT_1_7 clk_row_1__spl_6_o clk_row_1__spl_8_i clk_row_1__spl_7_i THmitll_SPLITT
XTHmitll_BUFFT_1_8 clk_row_1__spl_7_o THmitll_AND2T__clkbuf_6_i THmitll_BUFFT
XTHmitll_BUFFT_1_10 clk_row_1__spl_8_o THmitll_XORT__clkbuf_7_i THmitll_BUFFT
XTHmitll_SPLITT_2_0 clk_row_2_o clk_row_2__spl_6_i clk_row_2__spl_1_i THmitll_SPLITT
XTHmitll_SPLITT_2_1 clk_row_2__spl_1_o clk_row_2__spl_5_i clk_row_2__spl_2_i THmitll_SPLITT
XTHmitll_SPLITT_2_2 clk_row_2__spl_2_o clk_row_2__spl_4_i clk_row_2__spl_3_i THmitll_SPLITT
XTHmitll_BUFFT_2_5 clk_row_2__spl_5_o THmitll_DFFT__clkbuf_2_i THmitll_BUFFT
XTHmitll_SPLITT_2_7 clk_row_2__spl_6_o clk_row_2__spl_8_i clk_row_2__spl_7_i THmitll_SPLITT
XTHmitll_BUFFT_2_8 clk_row_2__spl_7_o THmitll_AND2T__clkbuf_3_i THmitll_BUFFT
XTHmitll_BUFFT_2_10 clk_row_2__spl_8_o THmitll_XORT__clkbuf_4_i THmitll_BUFFT
XTHmitll_SPLITT_3_0 clk_row_3__vbuf_2_o clk_row_3__spl_4_i clk_row_3__spl_1_i THmitll_SPLITT
XTHmitll_SPLITT_3_1 clk_row_3__spl_1_o clk_row_3__spl_3_i clk_row_3__spl_2_i THmitll_SPLITT
XTHmitll_SPLITT_3_4 clk_row_3__spl_4_o clk_row_3__spl_6_i clk_row_3__spl_5_i THmitll_SPLITT
XTHmitll_SPLITT_4_0 clk_row_4_o clk_row_4__spl_4_i clk_row_4__spl_1_i THmitll_SPLITT
XTHmitll_SPLITT_4_1 clk_row_4__spl_1_o clk_row_4__spl_3_i clk_row_4__spl_2_i THmitll_SPLITT
XTHmitll_SPLITT_4_4 clk_row_4__spl_4_o clk_row_4__spl_6_i clk_row_4__spl_5_i THmitll_SPLITT
XTHmitll_SPLITT_5_0 clk_row_5_o clk_row_5__spl_4_i clk_row_5__spl_1_i THmitll_SPLITT
XTHmitll_SPLITT_5_1 clk_row_5__spl_1_o clk_row_5__spl_3_i clk_row_5__spl_2_i THmitll_SPLITT
XTHmitll_BUFFT_5_4 clk_row_5__spl_4_o THmitll_OR2T__clkbuf_1_i THmitll_BUFFT
XTHmitll_SPLITT_sp0 clk_o clk_spine_1_i clk_row_5_i THmitll_SPLITT
XTHmitll_SPLITT_sp1 clk_spine_1_o clk_spine_2_i clk_row_4_i THmitll_SPLITT
XTHmitll_SPLITT_sp2 clk_spine_2_o clk_spine_3_i clk_row_3_i THmitll_SPLITT
XTHmitll_SPLITT_sp3 clk_spine_3_o clk_row_1_i clk_row_2_i THmitll_SPLITT
XTHmitll_JTLT_lm0 clk_row_1_o clk_row_1__vbuf_0_i THmitll_JTLT
XTHmitll_JTLT_lm1 x1__ff_2_o x1__ff_2__vbuf_1_i THmitll_JTLT
XTHmitll_JTLT_lm2 clk_row_3_o clk_row_3__vbuf_2_i THmitll_JTLT
