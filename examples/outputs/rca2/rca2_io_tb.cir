* rca2_tb.cir - generated by make_tb.py
* clock period 125 ps, 32 slots
* clock launch 50 ps, data launch 181.85 ps (data-clock 131.85 ps)
* input window 78.1 .. 185.6 ps relative to clock send

.include rca2.cir
.include lib/THmitll_DCSFQ-PTLTX_v3p0_extracted.cir
.include lib/THmitll_PTLRX-SFQDC_v3p0_extracted.cir

* ===== clock =====
I_clk 0 nclk pulse(0 600u 50p 2p 2p 3p 125p)
XSCLK THmitll_DCSFQ-PTLTX nclk clk_i

* ===== data inputs =====
* a0 = 00000000000000001111111111111111
I_a0 0 na0 PWL(0 0 2181.85p 0 2184.85p 600u 2187.85p 0 2306.85p 0 2309.85p 600u 2312.85p 0 2431.85p 0 2434.85p 600u 2437.85p 0 2556.85p 0 2559.85p 600u 2562.85p 0 2681.85p 0 2684.85p 600u 2687.85p 0 2806.85p 0 2809.85p 600u 2812.85p 0 2931.85p 0 2934.85p 600u 2937.85p 0 3056.85p 0 3059.85p 600u 3062.85p 0 3181.85p 0 3184.85p 600u 3187.85p 0 3306.85p 0 3309.85p 600u 3312.85p 0 3431.85p 0 3434.85p 600u 3437.85p 0 3556.85p 0 3559.85p 600u 3562.85p 0 3681.85p 0 3684.85p 600u 3687.85p 0 3806.85p 0 3809.85p 600u 3812.85p 0 3931.85p 0 3934.85p 600u 3937.85p 0 4056.85p 0 4059.85p 600u 4062.85p 0)
XSa0 THmitll_DCSFQ-PTLTX na0 a0_i
* a1 = 00000000111111110000000011111111
I_a1 0 na1 PWL(0 0 1181.85p 0 1184.85p 600u 1187.85p 0 1306.85p 0 1309.85p 600u 1312.85p 0 1431.85p 0 1434.85p 600u 1437.85p 0 1556.85p 0 1559.85p 600u 1562.85p 0 1681.85p 0 1684.85p 600u 1687.85p 0 1806.85p 0 1809.85p 600u 1812.85p 0 1931.85p 0 1934.85p 600u 1937.85p 0 2056.85p 0 2059.85p 600u 2062.85p 0 3181.85p 0 3184.85p 600u 3187.85p 0 3306.85p 0 3309.85p 600u 3312.85p 0 3431.85p 0 3434.85p 600u 3437.85p 0 3556.85p 0 3559.85p 600u 3562.85p 0 3681.85p 0 3684.85p 600u 3687.85p 0 3806.85p 0 3809.85p 600u 3812.85p 0 3931.85p 0 3934.85p 600u 3937.85p 0 4056.85p 0 4059.85p 600u 4062.85p 0)
XSa1 THmitll_DCSFQ-PTLTX na1 a1_i
* b0 = 00001111000011110000111100001111
I_b0 0 nb0 PWL(0 0 681.85p 0 684.85p 600u 687.85p 0 806.85p 0 809.85p 600u 812.85p 0 931.85p 0 934.85p 600u 937.85p 0 1056.85p 0 1059.85p 600u 1062.85p 0 1681.85p 0 1684.85p 600u 1687.85p 0 1806.85p 0 1809.85p 600u 1812.85p 0 1931.85p 0 1934.85p 600u 1937.85p 0 2056.85p 0 2059.85p 600u 2062.85p 0 2681.85p 0 2684.85p 600u 2687.85p 0 2806.85p 0 2809.85p 600u 2812.85p 0 2931.85p 0 2934.85p 600u 2937.85p 0 3056.85p 0 3059.85p 600u 3062.85p 0 3681.85p 0 3684.85p 600u 3687.85p 0 3806.85p 0 3809.85p 600u 3812.85p 0 3931.85p 0 3934.85p 600u 3937.85p 0 4056.85p 0 4059.85p 600u 4062.85p 0)
XSb0 THmitll_DCSFQ-PTLTX nb0 b0_i
* b1 = 00110011001100110011001100110011
I_b1 0 nb1 PWL(0 0 431.85p 0 434.85p 600u 437.85p 0 556.85p 0 559.85p 600u 562.85p 0 931.85p 0 934.85p 600u 937.85p 0 1056.85p 0 1059.85p 600u 1062.85p 0 1431.85p 0 1434.85p 600u 1437.85p 0 1556.85p 0 1559.85p 600u 1562.85p 0 1931.85p 0 1934.85p 600u 1937.85p 0 2056.85p 0 2059.85p 600u 2062.85p 0 2431.85p 0 2434.85p 600u 2437.85p 0 2556.85p 0 2559.85p 600u 2562.85p 0 2931.85p 0 2934.85p 600u 2937.85p 0 3056.85p 0 3059.85p 600u 3062.85p 0 3431.85p 0 3434.85p 600u 3437.85p 0 3556.85p 0 3559.85p 600u 3562.85p 0 3931.85p 0 3934.85p 600u 3937.85p 0 4056.85p 0 4059.85p 600u 4062.85p 0)
XSb1 THmitll_DCSFQ-PTLTX nb1 b1_i
* cin = 01010101010101010101010101010101
I_cin 0 ncin PWL(0 0 306.85p 0 309.85p 600u 312.85p 0 556.85p 0 559.85p 600u 562.85p 0 806.85p 0 809.85p 600u 812.85p 0 1056.85p 0 1059.85p 600u 1062.85p 0 1306.85p 0 1309.85p 600u 1312.85p 0 1556.85p 0 1559.85p 600u 1562.85p 0 1806.85p 0 1809.85p 600u 1812.85p 0 2056.85p 0 2059.85p 600u 2062.85p 0 2306.85p 0 2309.85p 600u 2312.85p 0 2556.85p 0 2559.85p 600u 2562.85p 0 2806.85p 0 2809.85p 600u 2812.85p 0 3056.85p 0 3059.85p 600u 3062.85p 0 3306.85p 0 3309.85p 600u 3312.85p 0 3556.85p 0 3559.85p 600u 3562.85p 0 3806.85p 0 3809.85p 600u 3812.85p 0 4056.85p 0 4059.85p 600u 4062.85p 0)
XScin THmitll_DCSFQ-PTLTX ncin cin_i

* ===== readout =====
XRs0 THmitll_PTLRX-SFQDC s0_o rs0
Rs0 rs0 0 2
XRs1 THmitll_PTLRX-SFQDC s1_o rs1
Rs1 rs1 0 2
XRcout THmitll_PTLRX-SFQDC cout_o rcout
Rcout rcout 0 2

* ===== analysis =====
* output watch 585 ps, decode window 710 ps (max depth 5, periods 4, travel 35 ps)
.tran 0.2p 4691.85p 0
.print v(clk_i) v(a0_i) v(a1_i) v(b0_i) v(b1_i) v(cin_i) v(s0_o) v(s1_o) v(cout_o)
.end
