* full_adder_tb.cir - generated by make_tb.py
* clock period 100 ps, 8 slots
* clock launch 50 ps, data launch 131.15 ps (data-clock 81.15 ps)
* input window 39.3 .. 123 ps relative to clock send

.include full_adder.cir
.include lib/THmitll_DCSFQ-PTLTX_v3p0_extracted.cir
.include lib/THmitll_PTLRX-SFQDC_v3p0_extracted.cir

* ===== clock =====
I_clk 0 nclk pulse(0 600u 50p 2p 2p 3p 100p)
XSCLK THmitll_DCSFQ-PTLTX nclk clk_i

* ===== data inputs =====
* a = 00001111
I_a 0 na PWL(0 0 531.15p 0 534.15p 600u 537.15p 0 631.15p 0 634.15p 600u 637.15p 0 731.15p 0 734.15p 600u 737.15p 0 831.15p 0 834.15p 600u 837.15p 0)
XSa THmitll_DCSFQ-PTLTX na a_i
* b = 00110011
I_b 0 nb PWL(0 0 331.15p 0 334.15p 600u 337.15p 0 431.15p 0 434.15p 600u 437.15p 0 731.15p 0 734.15p 600u 737.15p 0 831.15p 0 834.15p 600u 837.15p 0)
XSb THmitll_DCSFQ-PTLTX nb b_i
* cin = 01010101
I_cin 0 ncin PWL(0 0 231.15p 0 234.15p 600u 237.15p 0 431.15p 0 434.15p 600u 437.15p 0 631.15p 0 634.15p 600u 637.15p 0 831.15p 0 834.15p 600u 837.15p 0)
XScin THmitll_DCSFQ-PTLTX ncin cin_i

* ===== readout =====
XRsum THmitll_PTLRX-SFQDC sum_o rsum
Rsum rsum 0 2
XRcout THmitll_PTLRX-SFQDC cout_o rcout
Rcout rcout 0 2

* ===== analysis =====
* output watch 277.2 ps, decode window 377.2 ps (max depth 3, periods 2, travel 27.2 ps)
.tran 0.05p 1177.2p 0
.print v(clk_i) v(a_i) v(b_i) v(cin_i) v(sum_o) v(cout_o)
.end
