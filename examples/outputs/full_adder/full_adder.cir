* --- subcircuit includes ---
.include lib/PTL_M3.cir
.include lib/PTLCAP_M1.cir
.include lib/PTL_M1.cir
.include lib/VIA_M1_M3_STRAIGHT.cir
.include lib/BEND_PTL_M1.cir
.include lib/PTLCAP_M3.cir
.include lib/VIA_M1_M3_BENDS.cir
.include lib/BEND_PTL_M3.cir
.include lib/SPLIT_M5_3.cir
.include lib/SPLIT_M5_3_S.cir
.include lib/SPLIT_M5_3_WE.cir
.include lib/SPLIT_M5_4_SN.cir
.include lib/VIA_M1_M3_BENDN.cir
.include lib/THmitll_XORT_v3p0_extracted.cir
.include lib/THmitll_AND2T_v3p0_extracted.cir
.include lib/THmitll_OR2T_v3p0_extracted.cir
.include lib/THmitll_SPLITT_v3p0_extracted.cir
.include lib/THmitll_DFFT_v3p0_extracted.cir
.include lib/THmitll_BUFFT_v3p0_extracted.cir

* full_adder - SPICE netlist (flat)

* clock map: model=12 clock=21 clknet=8 clksig=8
Xcin__ff_1_t0 cin__ff_1_i cin__ff_1_1 PTLCAP_M1
Xcin__ff_1_t1 cin__ff_1_1 cin__ff_1_2 BEND_PTL_M1
Xcin__ff_1_t2 cin__ff_1_2 cin__ff_1_3 PTL_M1
Xcin__ff_1_t3 cin__ff_1_3 cin__ff_1_4 PTL_M1
Xcin__ff_1_t4 cin__ff_1_4 cin__ff_1_5 PTL_M1
Xcin__ff_1_t5 cin__ff_1_5 cin__ff_1_6 PTL_M1
Xcin__ff_1_t6 cin__ff_1_6 cin__ff_1_7 PTL_M1
Xcin__ff_1_t7 cin__ff_1_7 cin__ff_1_8 BEND_PTL_M1
Xcin__ff_1_t8 cin__ff_1_8 cin__ff_1_o PTLCAP_M1
Xclk_row_2__spl_1_t0 clk_row_2__spl_1_i clk_row_2__spl_1_1 PTLCAP_M1
Xclk_row_2__spl_1_t1 clk_row_2__spl_1_1 clk_row_2__spl_1_2 PTL_M1
Xclk_row_2__spl_1_t2 clk_row_2__spl_1_2 clk_row_2__spl_1_3 BEND_PTL_M1
Xclk_row_2__spl_1_t3 clk_row_2__spl_1_3 clk_row_2__spl_1_4 PTL_M1
Xclk_row_2__spl_1_t4 clk_row_2__spl_1_4 clk_row_2__spl_1_5 PTL_M1
Xclk_row_2__spl_1_t5 clk_row_2__spl_1_5 clk_row_2__spl_1_6 PTL_M1
Xclk_row_2__spl_1_t6 clk_row_2__spl_1_6 clk_row_2__spl_1_7 PTL_M1
Xclk_row_2__spl_1_t7 clk_row_2__spl_1_7 clk_row_2__spl_1_o PTLCAP_M1
Xclk_row_2__spl_4_t0 clk_row_2__spl_4_i clk_row_2__spl_4_1 PTLCAP_M1
Xclk_row_2__spl_4_t1 clk_row_2__spl_4_1 clk_row_2__spl_4_2 PTL_M1
Xclk_row_2__spl_4_t2 clk_row_2__spl_4_2 clk_row_2__spl_4_3 PTL_M1
Xclk_row_2__spl_4_t3 clk_row_2__spl_4_3 clk_row_2__spl_4_4 PTL_M1
Xclk_row_2__spl_4_t4 clk_row_2__spl_4_4 clk_row_2__spl_4_5 PTL_M1
Xclk_row_2__spl_4_t5 clk_row_2__spl_4_5 clk_row_2__spl_4_6 BEND_PTL_M1
Xclk_row_2__spl_4_t6 clk_row_2__spl_4_6 clk_row_2__spl_4_7 PTL_M1
Xclk_row_2__spl_4_t7 clk_row_2__spl_4_7 clk_row_2__spl_4_o PTLCAP_M1
Xclk_row_2__spl_3_t0 clk_row_2__spl_3_i clk_row_2__spl_3_1 PTLCAP_M1
Xclk_row_2__spl_3_t1 clk_row_2__spl_3_1 clk_row_2__spl_3_2 PTL_M1
Xclk_row_2__spl_3_t2 clk_row_2__spl_3_2 clk_row_2__spl_3_3 PTL_M1
Xclk_row_2__spl_3_t3 clk_row_2__spl_3_3 clk_row_2__spl_3_4 PTL_M1
Xclk_row_2__spl_3_t4 clk_row_2__spl_3_4 clk_row_2__spl_3_5 PTL_M1
Xclk_row_2__spl_3_t5 clk_row_2__spl_3_5 clk_row_2__spl_3_6 PTL_M1
Xclk_row_2__spl_3_t6 clk_row_2__spl_3_6 clk_row_2__spl_3_7 BEND_PTL_M1
Xclk_row_2__spl_3_t7 clk_row_2__spl_3_7 clk_row_2__spl_3_8 BEND_PTL_M1
Xclk_row_2__spl_3_t8 clk_row_2__spl_3_8 clk_row_2__spl_3_9 PTL_M1
Xclk_row_2__spl_3_t9 clk_row_2__spl_3_9 clk_row_2__spl_3_o PTLCAP_M1
Xclk_row_1__spl_4_t0 clk_row_1__spl_4_i clk_row_1__spl_4_1 PTLCAP_M1
Xclk_row_1__spl_4_t1 clk_row_1__spl_4_1 clk_row_1__spl_4_2 PTL_M1
Xclk_row_1__spl_4_t2 clk_row_1__spl_4_2 clk_row_1__spl_4_3 PTL_M1
Xclk_row_1__spl_4_t3 clk_row_1__spl_4_3 clk_row_1__spl_4_4 PTL_M1
Xclk_row_1__spl_4_t4 clk_row_1__spl_4_4 clk_row_1__spl_4_5 PTL_M1
Xclk_row_1__spl_4_t5 clk_row_1__spl_4_5 clk_row_1__spl_4_6 PTL_M1
Xclk_row_1__spl_4_t6 clk_row_1__spl_4_6 clk_row_1__spl_4_7 PTL_M1
Xclk_row_1__spl_4_t7 clk_row_1__spl_4_7 clk_row_1__spl_4_8 BEND_PTL_M1
Xclk_row_1__spl_4_t8 clk_row_1__spl_4_8 clk_row_1__spl_4_9 PTL_M1
Xclk_row_1__spl_4_t9 clk_row_1__spl_4_9 clk_row_1__spl_4_o PTLCAP_M1
Xclk_row_1__spl_1_t0 clk_row_1__spl_1_i clk_row_1__spl_1_1 PTLCAP_M1
Xclk_row_1__spl_1_t1 clk_row_1__spl_1_1 clk_row_1__spl_1_2 PTL_M1
Xclk_row_1__spl_1_t2 clk_row_1__spl_1_2 clk_row_1__spl_1_3 PTL_M1
Xclk_row_1__spl_1_t3 clk_row_1__spl_1_3 clk_row_1__spl_1_4 PTL_M1
Xclk_row_1__spl_1_t4 clk_row_1__spl_1_4 clk_row_1__spl_1_5 BEND_PTL_M1
Xclk_row_1__spl_1_t5 clk_row_1__spl_1_5 clk_row_1__spl_1_6 PTL_M1
Xclk_row_1__spl_1_t6 clk_row_1__spl_1_6 clk_row_1__spl_1_7 PTL_M1
Xclk_row_1__spl_1_t7 clk_row_1__spl_1_7 clk_row_1__spl_1_8 PTL_M1
Xclk_row_1__spl_1_t8 clk_row_1__spl_1_8 clk_row_1__spl_1_9 PTL_M1
Xclk_row_1__spl_1_t9 clk_row_1__spl_1_9 clk_row_1__spl_1_o PTLCAP_M1
XTHmitll_XORT__clkbuf_1_t0 THmitll_XORT__clkbuf_1_i THmitll_XORT__clkbuf_1_1 PTLCAP_M1
XTHmitll_XORT__clkbuf_1_t1 THmitll_XORT__clkbuf_1_1 THmitll_XORT__clkbuf_1_2 BEND_PTL_M1
XTHmitll_XORT__clkbuf_1_t2 THmitll_XORT__clkbuf_1_2 THmitll_XORT__clkbuf_1_3 PTL_M1
XTHmitll_XORT__clkbuf_1_t3 THmitll_XORT__clkbuf_1_3 THmitll_XORT__clkbuf_1_4 BEND_PTL_M1
XTHmitll_XORT__clkbuf_1_t4 THmitll_XORT__clkbuf_1_4 THmitll_XORT__clkbuf_1_5 PTL_M1
XTHmitll_XORT__clkbuf_1_t5 THmitll_XORT__clkbuf_1_5 THmitll_XORT__clkbuf_1_6 PTL_M1
XTHmitll_XORT__clkbuf_1_t6 THmitll_XORT__clkbuf_1_6 THmitll_XORT__clkbuf_1_7 PTL_M1
XTHmitll_XORT__clkbuf_1_t7 THmitll_XORT__clkbuf_1_7 THmitll_XORT__clkbuf_1_8 PTL_M1
XTHmitll_XORT__clkbuf_1_t8 THmitll_XORT__clkbuf_1_8 THmitll_XORT__clkbuf_1_9 PTL_M1
XTHmitll_XORT__clkbuf_1_t9 THmitll_XORT__clkbuf_1_9 THmitll_XORT__clkbuf_1_10 PTL_M1
XTHmitll_XORT__clkbuf_1_t10 THmitll_XORT__clkbuf_1_10 THmitll_XORT__clkbuf_1_11 PTL_M1
XTHmitll_XORT__clkbuf_1_t11 THmitll_XORT__clkbuf_1_11 THmitll_XORT__clkbuf_1_12 PTL_M1
XTHmitll_XORT__clkbuf_1_t12 THmitll_XORT__clkbuf_1_12 THmitll_XORT__clkbuf_1_o PTLCAP_M1
Xclk_row_2__spl_2_t0 clk_row_2__spl_2_i clk_row_2__spl_2_1 PTLCAP_M1
Xclk_row_2__spl_2_t1 clk_row_2__spl_2_1 clk_row_2__spl_2_2 BEND_PTL_M1
Xclk_row_2__spl_2_t2 clk_row_2__spl_2_2 clk_row_2__spl_2_3 PTL_M1
Xclk_row_2__spl_2_t3 clk_row_2__spl_2_3 clk_row_2__spl_2_4 PTL_M1
Xclk_row_2__spl_2_t4 clk_row_2__spl_2_4 clk_row_2__spl_2_5 PTL_M1
Xclk_row_2__spl_2_t5 clk_row_2__spl_2_5 clk_row_2__spl_2_6 PTL_M1
Xclk_row_2__spl_2_t6 clk_row_2__spl_2_6 clk_row_2__spl_2_7 PTL_M1
Xclk_row_2__spl_2_t7 clk_row_2__spl_2_7 clk_row_2__spl_2_8 PTL_M1
Xclk_row_2__spl_2_t8 clk_row_2__spl_2_8 clk_row_2__spl_2_9 PTL_M1
Xclk_row_2__spl_2_t9 clk_row_2__spl_2_9 clk_row_2__spl_2_10 PTL_M1
Xclk_row_2__spl_2_t10 clk_row_2__spl_2_10 clk_row_2__spl_2_11 PTL_M1
Xclk_row_2__spl_2_t11 clk_row_2__spl_2_11 clk_row_2__spl_2_12 BEND_PTL_M1
Xclk_row_2__spl_2_t12 clk_row_2__spl_2_12 clk_row_2__spl_2_13 PTL_M1
Xclk_row_2__spl_2_t13 clk_row_2__spl_2_13 clk_row_2__spl_2_14 PTL_M1
Xclk_row_2__spl_2_t14 clk_row_2__spl_2_14 clk_row_2__spl_2_15 PTL_M1
Xclk_row_2__spl_2_t15 clk_row_2__spl_2_15 clk_row_2__spl_2_16 BEND_PTL_M1
Xclk_row_2__spl_2_t16 clk_row_2__spl_2_16 clk_row_2__spl_2_o PTLCAP_M1
Xa_t0 a_i a_1 PTLCAP_M1
Xa_t1 a_1 a_2 BEND_PTL_M1
Xa_t2 a_2 a_3 PTL_M1
Xa_t3 a_3 a_4 PTL_M1
Xa_t4 a_4 a_5 PTL_M1
Xa_t5 a_5 a_6 PTL_M1
Xa_t6 a_6 a_7 PTL_M1
Xa_t7 a_7 a_8 PTL_M1
Xa_t8 a_8 a_9 PTL_M1
Xa_t9 a_9 a_10 PTL_M1
Xa_t10 a_10 a_11 PTL_M1
Xa_t11 a_11 a_12 PTL_M1
Xa_t12 a_12 a_13 PTL_M1
Xa_t13 a_13 a_o PTLCAP_M1
Xclk_row_3__spl_1_t0 clk_row_3__spl_1_i clk_row_3__spl_1_1 PTLCAP_M1
Xclk_row_3__spl_1_t1 clk_row_3__spl_1_1 clk_row_3__spl_1_2 PTL_M1
Xclk_row_3__spl_1_t2 clk_row_3__spl_1_2 clk_row_3__spl_1_3 PTL_M1
Xclk_row_3__spl_1_t3 clk_row_3__spl_1_3 clk_row_3__spl_1_4 PTL_M1
Xclk_row_3__spl_1_t4 clk_row_3__spl_1_4 clk_row_3__spl_1_5 PTL_M1
Xclk_row_3__spl_1_t5 clk_row_3__spl_1_5 clk_row_3__spl_1_6 BEND_PTL_M1
Xclk_row_3__spl_1_t6 clk_row_3__spl_1_6 clk_row_3__spl_1_7 PTL_M1
Xclk_row_3__spl_1_t7 clk_row_3__spl_1_7 clk_row_3__spl_1_8 PTL_M1
Xclk_row_3__spl_1_t8 clk_row_3__spl_1_8 clk_row_3__spl_1_9 PTL_M1
Xclk_row_3__spl_1_t9 clk_row_3__spl_1_9 clk_row_3__spl_1_10 PTL_M1
Xclk_row_3__spl_1_t10 clk_row_3__spl_1_10 clk_row_3__spl_1_11 PTL_M1
Xclk_row_3__spl_1_t11 clk_row_3__spl_1_11 clk_row_3__spl_1_12 PTL_M1
Xclk_row_3__spl_1_t12 clk_row_3__spl_1_12 clk_row_3__spl_1_13 PTL_M1
Xclk_row_3__spl_1_t13 clk_row_3__spl_1_13 clk_row_3__spl_1_o PTLCAP_M1
XTHmitll_XORT__clkbuf_2_t0 THmitll_XORT__clkbuf_2_i THmitll_XORT__clkbuf_2_1 PTLCAP_M1
XTHmitll_XORT__clkbuf_2_t1 THmitll_XORT__clkbuf_2_1 THmitll_XORT__clkbuf_2_2 BEND_PTL_M1
XTHmitll_XORT__clkbuf_2_t2 THmitll_XORT__clkbuf_2_2 THmitll_XORT__clkbuf_2_3 PTL_M1
XTHmitll_XORT__clkbuf_2_t3 THmitll_XORT__clkbuf_2_3 THmitll_XORT__clkbuf_2_4 PTL_M1
XTHmitll_XORT__clkbuf_2_t4 THmitll_XORT__clkbuf_2_4 THmitll_XORT__clkbuf_2_5 BEND_PTL_M1
XTHmitll_XORT__clkbuf_2_t5 THmitll_XORT__clkbuf_2_5 THmitll_XORT__clkbuf_2_6 PTL_M1
XTHmitll_XORT__clkbuf_2_t6 THmitll_XORT__clkbuf_2_6 THmitll_XORT__clkbuf_2_7 PTL_M1
XTHmitll_XORT__clkbuf_2_t7 THmitll_XORT__clkbuf_2_7 THmitll_XORT__clkbuf_2_8 PTL_M1
XTHmitll_XORT__clkbuf_2_t8 THmitll_XORT__clkbuf_2_8 THmitll_XORT__clkbuf_2_9 PTL_M1
XTHmitll_XORT__clkbuf_2_t9 THmitll_XORT__clkbuf_2_9 THmitll_XORT__clkbuf_2_10 PTL_M1
XTHmitll_XORT__clkbuf_2_t10 THmitll_XORT__clkbuf_2_10 THmitll_XORT__clkbuf_2_11 PTL_M1
XTHmitll_XORT__clkbuf_2_t11 THmitll_XORT__clkbuf_2_11 THmitll_XORT__clkbuf_2_12 PTL_M1
XTHmitll_XORT__clkbuf_2_t12 THmitll_XORT__clkbuf_2_12 THmitll_XORT__clkbuf_2_13 PTL_M1
XTHmitll_XORT__clkbuf_2_t13 THmitll_XORT__clkbuf_2_13 THmitll_XORT__clkbuf_2_14 PTL_M1
XTHmitll_XORT__clkbuf_2_t14 THmitll_XORT__clkbuf_2_14 THmitll_XORT__clkbuf_2_o PTLCAP_M1
Xs1_t0 s1_i s1_1 PTLCAP_M1
Xs1_t1 s1_1 s1_2 PTL_M1
Xs1_t2 s1_2 s1_3 PTL_M1
Xs1_t3 s1_3 s1_4 PTL_M1
Xs1_t4 s1_4 s1_5 PTL_M1
Xs1_t5 s1_5 s1_6 BEND_PTL_M1
Xs1_t6 s1_6 s1_7 PTL_M1
Xs1_t7 s1_7 s1_8 PTL_M1
Xs1_t8 s1_8 s1_9 PTL_M1
Xs1_t9 s1_9 s1_10 PTL_M1
Xs1_t10 s1_10 s1_11 PTL_M1
Xs1_t11 s1_11 s1_12 PTL_M1
Xs1_t12 s1_12 s1_13 PTL_M1
Xs1_t13 s1_13 s1_14 PTL_M1
Xs1_t14 s1_14 s1_15 BEND_PTL_M1
Xs1_t15 s1_15 s1_o PTLCAP_M1
Xa__spl_8_t0 a__spl_8_i a__spl_8_1 PTLCAP_M1
Xa__spl_8_t1 a__spl_8_1 a__spl_8_2 PTL_M1
Xa__spl_8_t2 a__spl_8_2 a__spl_8_3 BEND_PTL_M1
Xa__spl_8_t3 a__spl_8_3 a__spl_8_4 PTL_M1
Xa__spl_8_t4 a__spl_8_4 a__spl_8_5 PTL_M1
Xa__spl_8_t5 a__spl_8_5 a__spl_8_6 PTL_M1
Xa__spl_8_t6 a__spl_8_6 a__spl_8_7 PTL_M1
Xa__spl_8_t7 a__spl_8_7 a__spl_8_8 PTL_M1
Xa__spl_8_t8 a__spl_8_8 a__spl_8_9 PTL_M1
Xa__spl_8_t9 a__spl_8_9 a__spl_8_10 PTL_M1
Xa__spl_8_t10 a__spl_8_10 a__spl_8_11 PTL_M1
Xa__spl_8_t11 a__spl_8_11 a__spl_8_12 PTL_M1
Xa__spl_8_t12 a__spl_8_12 a__spl_8_13 PTL_M1
Xa__spl_8_t13 a__spl_8_13 a__spl_8_14 PTL_M1
Xa__spl_8_t14 a__spl_8_14 a__spl_8_15 PTL_M1
Xa__spl_8_t15 a__spl_8_15 a__spl_8_16 PTL_M1
Xa__spl_8_t16 a__spl_8_16 a__spl_8_o PTLCAP_M1
Xb_t0 b_i b_1 PTLCAP_M1
Xb_t1 b_1 b_2 PTL_M1
Xb_t2 b_2 b_3 PTL_M1
Xb_t3 b_3 b_4 PTL_M1
Xb_t4 b_4 b_5 BEND_PTL_M1
Xb_t5 b_5 b_6 PTL_M1
Xb_t6 b_6 b_7 PTL_M1
Xb_t7 b_7 b_8 PTL_M1
Xb_t8 b_8 b_9 PTL_M1
Xb_t9 b_9 b_10 PTL_M1
Xb_t10 b_10 b_11 PTL_M1
Xb_t11 b_11 b_12 PTL_M1
Xb_t12 b_12 b_13 PTL_M1
Xb_t13 b_13 b_14 PTL_M1
Xb_t14 b_14 b_15 PTL_M1
Xb_t15 b_15 b_16 PTL_M1
Xb_t16 b_16 b_o PTLCAP_M1
Xclk_row_1__spl_2_t0 clk_row_1__spl_2_i clk_row_1__spl_2_1 PTLCAP_M1
Xclk_row_1__spl_2_t1 clk_row_1__spl_2_1 clk_row_1__spl_2_2 PTL_M1
Xclk_row_1__spl_2_t2 clk_row_1__spl_2_2 clk_row_1__spl_2_3 PTL_M1
Xclk_row_1__spl_2_t3 clk_row_1__spl_2_3 clk_row_1__spl_2_4 PTL_M1
Xclk_row_1__spl_2_t4 clk_row_1__spl_2_4 clk_row_1__spl_2_5 PTL_M1
Xclk_row_1__spl_2_t5 clk_row_1__spl_2_5 clk_row_1__spl_2_6 PTL_M1
Xclk_row_1__spl_2_t6 clk_row_1__spl_2_6 clk_row_1__spl_2_7 PTL_M1
Xclk_row_1__spl_2_t7 clk_row_1__spl_2_7 clk_row_1__spl_2_8 BEND_PTL_M1
Xclk_row_1__spl_2_t8 clk_row_1__spl_2_8 clk_row_1__spl_2_9 PTL_M1
Xclk_row_1__spl_2_t9 clk_row_1__spl_2_9 clk_row_1__spl_2_10 PTL_M1
Xclk_row_1__spl_2_t10 clk_row_1__spl_2_10 clk_row_1__spl_2_11 PTL_M1
Xclk_row_1__spl_2_t11 clk_row_1__spl_2_11 clk_row_1__spl_2_12 PTL_M1
Xclk_row_1__spl_2_t12 clk_row_1__spl_2_12 clk_row_1__spl_2_13 PTL_M1
Xclk_row_1__spl_2_t13 clk_row_1__spl_2_13 clk_row_1__spl_2_14 PTL_M1
Xclk_row_1__spl_2_t14 clk_row_1__spl_2_14 clk_row_1__spl_2_15 PTL_M1
Xclk_row_1__spl_2_t15 clk_row_1__spl_2_15 clk_row_1__spl_2_16 PTL_M1
Xclk_row_1__spl_2_t16 clk_row_1__spl_2_16 clk_row_1__spl_2_17 PTL_M1
Xclk_row_1__spl_2_t17 clk_row_1__spl_2_17 clk_row_1__spl_2_o PTLCAP_M1
Xclk_t0 clk_i clk_1 PTLCAP_M1
Xclk_t1 clk_1 clk_2 PTL_M1
Xclk_t2 clk_2 clk_3 PTL_M1
Xclk_t3 clk_3 clk_4 PTL_M1
Xclk_t4 clk_4 clk_5 PTL_M1
Xclk_t5 clk_5 clk_6 PTL_M1
Xclk_t6 clk_6 clk_7 PTL_M1
Xclk_t7 clk_7 clk_8 PTL_M1
Xclk_t8 clk_8 clk_9 PTL_M1
Xclk_t9 clk_9 clk_10 PTL_M1
Xclk_t10 clk_10 clk_11 PTL_M1
Xclk_t11 clk_11 clk_12 PTL_M1
Xclk_t12 clk_12 clk_13 PTL_M1
Xclk_t13 clk_13 clk_14 PTL_M1
Xclk_t14 clk_14 clk_15 BEND_PTL_M1
Xclk_t15 clk_15 clk_16 PTL_M1
Xclk_t16 clk_16 clk_17 PTL_M1
Xclk_t17 clk_17 clk_o PTLCAP_M1
Xb__spl_1_t0 b__spl_1_i b__spl_1_1 PTLCAP_M1
Xb__spl_1_t1 b__spl_1_1 b__spl_1_2 BEND_PTL_M1
Xb__spl_1_t2 b__spl_1_2 b__spl_1_3 PTL_M1
Xb__spl_1_t3 b__spl_1_3 b__spl_1_4 BEND_PTL_M1
Xb__spl_1_t4 b__spl_1_4 b__spl_1_5 PTL_M1
Xb__spl_1_t5 b__spl_1_5 b__spl_1_6 PTL_M1
Xb__spl_1_t6 b__spl_1_6 b__spl_1_7 PTL_M1
Xb__spl_1_t7 b__spl_1_7 b__spl_1_8 BEND_PTL_M1
Xb__spl_1_t8 b__spl_1_8 b__spl_1_9 PTL_M1
Xb__spl_1_t9 b__spl_1_9 b__spl_1_10 PTL_M1
Xb__spl_1_t10 b__spl_1_10 b__spl_1_11 PTL_M1
Xb__spl_1_t11 b__spl_1_11 b__spl_1_12 PTL_M1
Xb__spl_1_t12 b__spl_1_12 b__spl_1_13 PTL_M1
Xb__spl_1_t13 b__spl_1_13 b__spl_1_14 PTL_M1
Xb__spl_1_t14 b__spl_1_14 b__spl_1_15 PTL_M1
Xb__spl_1_t15 b__spl_1_15 b__spl_1_16 PTL_M1
Xb__spl_1_t16 b__spl_1_16 b__spl_1_17 PTL_M1
Xb__spl_1_t17 b__spl_1_17 b__spl_1_18 PTL_M1
Xb__spl_1_t18 b__spl_1_18 b__spl_1_19 PTL_M1
Xb__spl_1_t19 b__spl_1_19 b__spl_1_20 PTL_M1
Xb__spl_1_t20 b__spl_1_20 b__spl_1_21 PTL_M1
Xb__spl_1_t21 b__spl_1_21 b__spl_1_22 PTL_M1
Xb__spl_1_t22 b__spl_1_22 b__spl_1_o PTLCAP_M1
Xclk_row_1__spl_3_t0 clk_row_1__spl_3_i clk_row_1__spl_3_1 PTLCAP_M1
Xclk_row_1__spl_3_t1 clk_row_1__spl_3_1 clk_row_1__spl_3_2 PTL_M1
Xclk_row_1__spl_3_t2 clk_row_1__spl_3_2 clk_row_1__spl_3_3 PTL_M1
Xclk_row_1__spl_3_t3 clk_row_1__spl_3_3 clk_row_1__spl_3_4 PTL_M1
Xclk_row_1__spl_3_t4 clk_row_1__spl_3_4 clk_row_1__spl_3_5 PTL_M1
Xclk_row_1__spl_3_t5 clk_row_1__spl_3_5 clk_row_1__spl_3_6 PTL_M1
Xclk_row_1__spl_3_t6 clk_row_1__spl_3_6 clk_row_1__spl_3_7 PTL_M1
Xclk_row_1__spl_3_t7 clk_row_1__spl_3_7 clk_row_1__spl_3_8 BEND_PTL_M1
Xclk_row_1__spl_3_t8 clk_row_1__spl_3_8 clk_row_1__spl_3_9 PTL_M1
Xclk_row_1__spl_3_t9 clk_row_1__spl_3_9 clk_row_1__spl_3_10 PTL_M1
Xclk_row_1__spl_3_t10 clk_row_1__spl_3_10 clk_row_1__spl_3_11 PTL_M1
Xclk_row_1__spl_3_t11 clk_row_1__spl_3_11 clk_row_1__spl_3_12 PTL_M1
Xclk_row_1__spl_3_t12 clk_row_1__spl_3_12 clk_row_1__spl_3_13 PTL_M1
Xclk_row_1__spl_3_t13 clk_row_1__spl_3_13 clk_row_1__spl_3_14 PTL_M1
Xclk_row_1__spl_3_t14 clk_row_1__spl_3_14 clk_row_1__spl_3_15 PTL_M1
Xclk_row_1__spl_3_t15 clk_row_1__spl_3_15 clk_row_1__spl_3_16 PTL_M1
Xclk_row_1__spl_3_t16 clk_row_1__spl_3_16 clk_row_1__spl_3_17 PTL_M1
Xclk_row_1__spl_3_t17 clk_row_1__spl_3_17 clk_row_1__spl_3_18 BEND_PTL_M1
Xclk_row_1__spl_3_t18 clk_row_1__spl_3_18 clk_row_1__spl_3_19 PTL_M1
Xclk_row_1__spl_3_t19 clk_row_1__spl_3_19 clk_row_1__spl_3_o PTLCAP_M1
Xclk_row_3__spl_2_t0 clk_row_3__spl_2_i clk_row_3__spl_2_1 PTLCAP_M1
Xclk_row_3__spl_2_t1 clk_row_3__spl_2_1 clk_row_3__spl_2_2 PTL_M1
Xclk_row_3__spl_2_t2 clk_row_3__spl_2_2 clk_row_3__spl_2_3 PTL_M1
Xclk_row_3__spl_2_t3 clk_row_3__spl_2_3 clk_row_3__spl_2_4 PTL_M1
Xclk_row_3__spl_2_t4 clk_row_3__spl_2_4 clk_row_3__spl_2_5 PTL_M1
Xclk_row_3__spl_2_t5 clk_row_3__spl_2_5 clk_row_3__spl_2_6 PTL_M1
Xclk_row_3__spl_2_t6 clk_row_3__spl_2_6 clk_row_3__spl_2_7 PTL_M1
Xclk_row_3__spl_2_t7 clk_row_3__spl_2_7 clk_row_3__spl_2_8 PTL_M1
Xclk_row_3__spl_2_t8 clk_row_3__spl_2_8 clk_row_3__spl_2_9 PTL_M1
Xclk_row_3__spl_2_t9 clk_row_3__spl_2_9 clk_row_3__spl_2_10 PTL_M1
Xclk_row_3__spl_2_t10 clk_row_3__spl_2_10 clk_row_3__spl_2_11 PTL_M1
Xclk_row_3__spl_2_t11 clk_row_3__spl_2_11 clk_row_3__spl_2_12 PTL_M1
Xclk_row_3__spl_2_t12 clk_row_3__spl_2_12 clk_row_3__spl_2_13 BEND_PTL_M1
Xclk_row_3__spl_2_t13 clk_row_3__spl_2_13 clk_row_3__spl_2_14 PTL_M1
Xclk_row_3__spl_2_t14 clk_row_3__spl_2_14 clk_row_3__spl_2_15 PTL_M1
Xclk_row_3__spl_2_t15 clk_row_3__spl_2_15 clk_row_3__spl_2_16 PTL_M1
Xclk_row_3__spl_2_t16 clk_row_3__spl_2_16 clk_row_3__spl_2_17 PTL_M1
Xclk_row_3__spl_2_t17 clk_row_3__spl_2_17 clk_row_3__spl_2_18 PTL_M1
Xclk_row_3__spl_2_t18 clk_row_3__spl_2_18 clk_row_3__spl_2_19 BEND_PTL_M1
Xclk_row_3__spl_2_t19 clk_row_3__spl_2_19 clk_row_3__spl_2_o PTLCAP_M1
Xb__spl_2_t0 b__spl_2_i b__spl_2_1 PTLCAP_M1
Xb__spl_2_t1 b__spl_2_1 b__spl_2_2 PTL_M1
Xb__spl_2_t2 b__spl_2_2 b__spl_2_3 PTL_M1
Xb__spl_2_t3 b__spl_2_3 b__spl_2_4 PTL_M1
Xb__spl_2_t4 b__spl_2_4 b__spl_2_5 PTL_M1
Xb__spl_2_t5 b__spl_2_5 b__spl_2_6 BEND_PTL_M1
Xb__spl_2_t6 b__spl_2_6 b__spl_2_7 PTL_M1
Xb__spl_2_t7 b__spl_2_7 b__spl_2_8 PTL_M1
Xb__spl_2_t8 b__spl_2_8 b__spl_2_9 PTL_M1
Xb__spl_2_t9 b__spl_2_9 b__spl_2_10 PTL_M1
Xb__spl_2_t10 b__spl_2_10 b__spl_2_11 PTL_M1
Xb__spl_2_t11 b__spl_2_11 b__spl_2_12 PTL_M1
Xb__spl_2_t12 b__spl_2_12 b__spl_2_13 PTL_M1
Xb__spl_2_t13 b__spl_2_13 b__spl_2_14 PTL_M1
Xb__spl_2_t14 b__spl_2_14 b__spl_2_15 PTL_M1
Xb__spl_2_t15 b__spl_2_15 b__spl_2_16 PTL_M1
Xb__spl_2_t16 b__spl_2_16 b__spl_2_17 PTL_M1
Xb__spl_2_t17 b__spl_2_17 b__spl_2_18 PTL_M1
Xb__spl_2_t18 b__spl_2_18 b__spl_2_19 PTL_M1
Xb__spl_2_t19 b__spl_2_19 b__spl_2_20 PTL_M1
Xb__spl_2_t20 b__spl_2_20 b__spl_2_21 PTL_M1
Xb__spl_2_t21 b__spl_2_21 b__spl_2_22 PTL_M1
Xb__spl_2_t22 b__spl_2_22 b__spl_2_23 BEND_PTL_M1
Xb__spl_2_t23 b__spl_2_23 b__spl_2_24 PTL_M1
Xb__spl_2_t24 b__spl_2_24 b__spl_2_25 PTL_M1
Xb__spl_2_t25 b__spl_2_25 b__spl_2_26 BEND_PTL_M1
Xb__spl_2_t26 b__spl_2_26 b__spl_2_27 PTL_M1
Xb__spl_2_t27 b__spl_2_27 b__spl_2_28 BEND_PTL_M1
Xb__spl_2_t28 b__spl_2_28 b__spl_2_o PTLCAP_M1
Xp1__ff_1_t0 p1__ff_1_i p1__ff_1_1 PTLCAP_M1
Xp1__ff_1_t1 p1__ff_1_1 p1__ff_1_2 PTL_M1
Xp1__ff_1_t2 p1__ff_1_2 p1__ff_1_3 PTL_M1
Xp1__ff_1_t3 p1__ff_1_3 p1__ff_1_4 PTL_M1
Xp1__ff_1_t4 p1__ff_1_4 p1__ff_1_5 BEND_PTL_M1
Xp1__ff_1_t5 p1__ff_1_5 p1__ff_1_6 PTL_M1
Xp1__ff_1_t6 p1__ff_1_6 p1__ff_1_7 PTL_M1
Xp1__ff_1_t7 p1__ff_1_7 p1__ff_1_8 PTL_M1
Xp1__ff_1_t8 p1__ff_1_8 p1__ff_1_9 PTL_M1
Xp1__ff_1_t9 p1__ff_1_9 p1__ff_1_10 BEND_PTL_M1
Xp1__ff_1_t10 p1__ff_1_10 p1__ff_1_11 PTL_M1
Xp1__ff_1_t11 p1__ff_1_11 p1__ff_1_12 PTL_M1
Xp1__ff_1_t12 p1__ff_1_12 p1__ff_1_13 PTL_M1
Xp1__ff_1_t13 p1__ff_1_13 p1__ff_1_14 PTL_M1
Xp1__ff_1_t14 p1__ff_1_14 p1__ff_1_15 PTL_M1
Xp1__ff_1_t15 p1__ff_1_15 p1__ff_1_16 PTL_M1
Xp1__ff_1_t16 p1__ff_1_16 p1__ff_1_17 PTL_M1
Xp1__ff_1_t17 p1__ff_1_17 p1__ff_1_18 PTL_M1
Xp1__ff_1_t18 p1__ff_1_18 p1__ff_1_19 PTL_M1
Xp1__ff_1_t19 p1__ff_1_19 p1__ff_1_20 PTL_M1
Xp1__ff_1_t20 p1__ff_1_20 p1__ff_1_21 PTL_M1
Xp1__ff_1_t21 p1__ff_1_21 p1__ff_1_22 PTL_M1
Xp1__ff_1_t22 p1__ff_1_22 p1__ff_1_23 PTL_M1
Xp1__ff_1_t23 p1__ff_1_23 p1__ff_1_24 PTL_M1
Xp1__ff_1_t24 p1__ff_1_24 p1__ff_1_25 BEND_PTL_M1
Xp1__ff_1_t25 p1__ff_1_25 p1__ff_1_26 PTL_M1
Xp1__ff_1_t26 p1__ff_1_26 p1__ff_1_27 PTL_M1
Xp1__ff_1_t27 p1__ff_1_27 p1__ff_1_28 PTL_M1
Xp1__ff_1_t28 p1__ff_1_28 p1__ff_1_29 BEND_PTL_M1
Xp1__ff_1_t29 p1__ff_1_29 p1__ff_1_o PTLCAP_M1
Xcout_t0 cout_i cout_1 PTLCAP_M1
Xcout_t1 cout_1 cout_2 PTL_M1
Xcout_t2 cout_2 cout_3 PTL_M1
Xcout_t3 cout_3 cout_4 PTL_M1
Xcout_t4 cout_4 cout_5 PTL_M1
Xcout_t5 cout_5 cout_6 PTL_M1
Xcout_t6 cout_6 cout_7 PTL_M1
Xcout_t7 cout_7 cout_8 PTL_M1
Xcout_t8 cout_8 cout_9 PTL_M1
Xcout_t9 cout_9 cout_10 PTL_M1
Xcout_t10 cout_10 cout_11 PTL_M1
Xcout_t11 cout_11 cout_12 PTL_M1
Xcout_t12 cout_12 cout_13 PTL_M1
Xcout_t13 cout_13 cout_14 PTL_M1
Xcout_t14 cout_14 cout_15 PTL_M1
Xcout_t15 cout_15 cout_16 PTL_M1
Xcout_t16 cout_16 cout_17 PTL_M1
Xcout_t17 cout_17 cout_18 PTL_M1
Xcout_t18 cout_18 cout_19 PTL_M1
Xcout_t19 cout_19 cout_20 PTL_M1
Xcout_t20 cout_20 cout_21 PTL_M1
Xcout_t21 cout_21 cout_22 BEND_PTL_M1
Xcout_t22 cout_22 cout_o PTLCAP_M1
Xs1__spl_6_t0 s1__spl_6_i s1__spl_6_1 PTLCAP_M1
Xs1__spl_6_t1 s1__spl_6_1 s1__spl_6_2 PTL_M1
Xs1__spl_6_t2 s1__spl_6_2 s1__spl_6_3 PTL_M1
Xs1__spl_6_t3 s1__spl_6_3 s1__spl_6_4 PTL_M1
Xs1__spl_6_t4 s1__spl_6_4 s1__spl_6_5 BEND_PTL_M1
Xs1__spl_6_t5 s1__spl_6_5 s1__spl_6_6 BEND_PTL_M1
Xs1__spl_6_t6 s1__spl_6_6 s1__spl_6_7 PTL_M1
Xs1__spl_6_t7 s1__spl_6_7 s1__spl_6_8 PTL_M1
Xs1__spl_6_t8 s1__spl_6_8 s1__spl_6_9 PTL_M1
Xs1__spl_6_t9 s1__spl_6_9 s1__spl_6_10 PTL_M1
Xs1__spl_6_t10 s1__spl_6_10 s1__spl_6_11 PTL_M1
Xs1__spl_6_t11 s1__spl_6_11 s1__spl_6_12 BEND_PTL_M1
Xs1__spl_6_t12 s1__spl_6_12 s1__spl_6_13 PTL_M1
Xs1__spl_6_t13 s1__spl_6_13 s1__spl_6_14 PTL_M1
Xs1__spl_6_t14 s1__spl_6_14 s1__spl_6_15 PTL_M1
Xs1__spl_6_t15 s1__spl_6_15 s1__spl_6_16 PTL_M1
Xs1__spl_6_t16 s1__spl_6_16 s1__spl_6_17 PTL_M1
Xs1__spl_6_t17 s1__spl_6_17 s1__spl_6_18 PTL_M1
Xs1__spl_6_t18 s1__spl_6_18 s1__spl_6_19 PTL_M1
Xs1__spl_6_t19 s1__spl_6_19 s1__spl_6_20 PTL_M1
Xs1__spl_6_t20 s1__spl_6_20 s1__spl_6_21 PTL_M1
Xs1__spl_6_t21 s1__spl_6_21 s1__spl_6_22 PTL_M1
Xs1__spl_6_t22 s1__spl_6_22 s1__spl_6_23 PTL_M1
Xs1__spl_6_t23 s1__spl_6_23 s1__spl_6_24 PTL_M1
Xs1__spl_6_t24 s1__spl_6_24 s1__spl_6_25 PTL_M1
Xs1__spl_6_t25 s1__spl_6_25 s1__spl_6_26 PTL_M1
Xs1__spl_6_t26 s1__spl_6_26 s1__spl_6_27 PTL_M1
Xs1__spl_6_t27 s1__spl_6_27 s1__spl_6_28 PTL_M1
Xs1__spl_6_t28 s1__spl_6_28 s1__spl_6_29 PTL_M1
Xs1__spl_6_t29 s1__spl_6_29 s1__spl_6_30 BEND_PTL_M1
Xs1__spl_6_t30 s1__spl_6_30 s1__spl_6_31 PTL_M1
Xs1__spl_6_t31 s1__spl_6_31 s1__spl_6_32 PTL_M1
Xs1__spl_6_t32 s1__spl_6_32 s1__spl_6_33 PTL_M1
Xs1__spl_6_t33 s1__spl_6_33 s1__spl_6_34 PTL_M1
Xs1__spl_6_t34 s1__spl_6_34 s1__spl_6_35 PTL_M1
Xs1__spl_6_t35 s1__spl_6_35 s1__spl_6_36 BEND_PTL_M1
Xs1__spl_6_t36 s1__spl_6_36 s1__spl_6_o PTLCAP_M1
Xs1__spl_5_t0 s1__spl_5_i s1__spl_5_1 PTLCAP_M1
Xs1__spl_5_t1 s1__spl_5_1 s1__spl_5_2 PTL_M1
Xs1__spl_5_t2 s1__spl_5_2 s1__spl_5_3 BEND_PTL_M1
Xs1__spl_5_t3 s1__spl_5_3 s1__spl_5_4 BEND_PTL_M1
Xs1__spl_5_t4 s1__spl_5_4 s1__spl_5_5 PTL_M1
Xs1__spl_5_t5 s1__spl_5_5 s1__spl_5_6 PTL_M1
Xs1__spl_5_t6 s1__spl_5_6 s1__spl_5_7 PTL_M1
Xs1__spl_5_t7 s1__spl_5_7 s1__spl_5_8 BEND_PTL_M1
Xs1__spl_5_t8 s1__spl_5_8 s1__spl_5_9 BEND_PTL_M1
Xs1__spl_5_t9 s1__spl_5_9 s1__spl_5_10 PTL_M1
Xs1__spl_5_t10 s1__spl_5_10 s1__spl_5_11 PTL_M1
Xs1__spl_5_t11 s1__spl_5_11 s1__spl_5_12 PTL_M1
Xs1__spl_5_t12 s1__spl_5_12 s1__spl_5_13 BEND_PTL_M1
Xs1__spl_5_t13 s1__spl_5_13 s1__spl_5_14 PTL_M1
Xs1__spl_5_t14 s1__spl_5_14 s1__spl_5_15 PTL_M1
Xs1__spl_5_t15 s1__spl_5_15 s1__spl_5_16 BEND_PTL_M1
Xs1__spl_5_t16 s1__spl_5_16 s1__spl_5_17 PTL_M1
Xs1__spl_5_t17 s1__spl_5_17 s1__spl_5_18 PTL_M1
Xs1__spl_5_t18 s1__spl_5_18 s1__spl_5_19 BEND_PTL_M1
Xs1__spl_5_t19 s1__spl_5_19 s1__spl_5_20 PTL_M1
Xs1__spl_5_t20 s1__spl_5_20 s1__spl_5_21 PTL_M1
Xs1__spl_5_t21 s1__spl_5_21 s1__spl_5_22 BEND_PTL_M1
Xs1__spl_5_t22 s1__spl_5_22 s1__spl_5_23 PTL_M1
Xs1__spl_5_t23 s1__spl_5_23 s1__spl_5_24 BEND_PTL_M1
Xs1__spl_5_t24 s1__spl_5_24 s1__spl_5_25 PTL_M1
Xs1__spl_5_t25 s1__spl_5_25 s1__spl_5_26 PTL_M1
Xs1__spl_5_t26 s1__spl_5_26 s1__spl_5_27 PTL_M1
Xs1__spl_5_t27 s1__spl_5_27 s1__spl_5_28 PTL_M1
Xs1__spl_5_t28 s1__spl_5_28 s1__spl_5_29 PTL_M1
Xs1__spl_5_t29 s1__spl_5_29 s1__spl_5_30 PTL_M1
Xs1__spl_5_t30 s1__spl_5_30 s1__spl_5_31 PTL_M1
Xs1__spl_5_t31 s1__spl_5_31 s1__spl_5_32 PTL_M1
Xs1__spl_5_t32 s1__spl_5_32 s1__spl_5_33 PTL_M1
Xs1__spl_5_t33 s1__spl_5_33 s1__spl_5_34 PTL_M1
Xs1__spl_5_t34 s1__spl_5_34 s1__spl_5_35 PTL_M1
Xs1__spl_5_t35 s1__spl_5_35 s1__spl_5_36 PTL_M1
Xs1__spl_5_t36 s1__spl_5_36 s1__spl_5_37 PTL_M1
Xs1__spl_5_t37 s1__spl_5_37 s1__spl_5_38 PTL_M1
Xs1__spl_5_t38 s1__spl_5_38 s1__spl_5_39 PTL_M1
Xs1__spl_5_t39 s1__spl_5_39 s1__spl_5_40 PTL_M1
Xs1__spl_5_t40 s1__spl_5_40 s1__spl_5_41 BEND_PTL_M1
Xs1__spl_5_t41 s1__spl_5_41 s1__spl_5_42 PTL_M1
Xs1__spl_5_t42 s1__spl_5_42 s1__spl_5_43 PTL_M1
Xs1__spl_5_t43 s1__spl_5_43 s1__spl_5_44 PTL_M1
Xs1__spl_5_t44 s1__spl_5_44 s1__spl_5_45 PTL_M1
Xs1__spl_5_t45 s1__spl_5_45 s1__spl_5_46 PTL_M1
Xs1__spl_5_t46 s1__spl_5_46 s1__spl_5_47 PTL_M1
Xs1__spl_5_t47 s1__spl_5_47 s1__spl_5_48 PTL_M1
Xs1__spl_5_t48 s1__spl_5_48 s1__spl_5_o PTLCAP_M1
Xclk_row_2_t0 clk_row_2_i clk_row_2_1 PTLCAP_M1
Xclk_row_2_t1 clk_row_2_1 clk_row_2_2 PTL_M1
Xclk_row_2_t2 clk_row_2_2 clk_row_2_3 PTL_M1
Xclk_row_2_t3 clk_row_2_3 clk_row_2_4 PTL_M1
Xclk_row_2_t4 clk_row_2_4 clk_row_2_5 PTL_M1
Xclk_row_2_t5 clk_row_2_5 clk_row_2_6 PTL_M1
Xclk_row_2_t6 clk_row_2_6 clk_row_2_7 PTL_M1
Xclk_row_2_t7 clk_row_2_7 clk_row_2_8 PTL_M1
Xclk_row_2_t8 clk_row_2_8 clk_row_2_9 PTL_M1
Xclk_row_2_t9 clk_row_2_9 clk_row_2_10 PTL_M1
Xclk_row_2_t10 clk_row_2_10 clk_row_2_11 PTL_M1
Xclk_row_2_t11 clk_row_2_11 clk_row_2_12 PTL_M1
Xclk_row_2_t12 clk_row_2_12 clk_row_2_13 PTL_M1
Xclk_row_2_t13 clk_row_2_13 clk_row_2_14 PTL_M1
Xclk_row_2_t14 clk_row_2_14 clk_row_2_15 PTL_M1
Xclk_row_2_t15 clk_row_2_15 clk_row_2_16 BEND_PTL_M1
Xclk_row_2_t16 clk_row_2_16 clk_row_2_17 PTL_M1
Xclk_row_2_t17 clk_row_2_17 clk_row_2_18 PTL_M1
Xclk_row_2_t18 clk_row_2_18 clk_row_2_19 PTL_M1
Xclk_row_2_t19 clk_row_2_19 clk_row_2_20 PTL_M1
Xclk_row_2_t20 clk_row_2_20 clk_row_2_21 PTL_M1
Xclk_row_2_t21 clk_row_2_21 clk_row_2_22 PTL_M1
Xclk_row_2_t22 clk_row_2_22 clk_row_2_23 PTL_M1
Xclk_row_2_t23 clk_row_2_23 clk_row_2_24 PTL_M1
Xclk_row_2_t24 clk_row_2_24 clk_row_2_25 PTL_M1
Xclk_row_2_t25 clk_row_2_25 clk_row_2_26 PTL_M1
Xclk_row_2_t26 clk_row_2_26 clk_row_2_27 PTL_M1
Xclk_row_2_t27 clk_row_2_27 clk_row_2_28 PTL_M1
Xclk_row_2_t28 clk_row_2_28 clk_row_2_29 PTL_M1
Xclk_row_2_t29 clk_row_2_29 clk_row_2_30 BEND_PTL_M1
Xclk_row_2_t30 clk_row_2_30 clk_row_2_31 PTL_M1
Xclk_row_2_t31 clk_row_2_31 clk_row_2_32 BEND_PTL_M1
Xclk_row_2_t32 clk_row_2_32 clk_row_2_33 PTL_M1
Xclk_row_2_t33 clk_row_2_33 clk_row_2_34 PTL_M1
Xclk_row_2_t34 clk_row_2_34 clk_row_2_35 PTL_M1
Xclk_row_2_t35 clk_row_2_35 clk_row_2_36 BEND_PTL_M1
Xclk_row_2_t36 clk_row_2_36 clk_row_2_37 PTL_M1
Xclk_row_2_t37 clk_row_2_37 clk_row_2_38 PTL_M1
Xclk_row_2_t38 clk_row_2_38 clk_row_2_39 PTL_M1
Xclk_row_2_t39 clk_row_2_39 clk_row_2_40 PTL_M1
Xclk_row_2_t40 clk_row_2_40 clk_row_2_41 PTL_M1
Xclk_row_2_t41 clk_row_2_41 clk_row_2_42 PTL_M1
Xclk_row_2_t42 clk_row_2_42 clk_row_2_43 PTL_M1
Xclk_row_2_t43 clk_row_2_43 clk_row_2_44 PTL_M1
Xclk_row_2_t44 clk_row_2_44 clk_row_2_45 PTL_M1
Xclk_row_2_t45 clk_row_2_45 clk_row_2_46 PTL_M1
Xclk_row_2_t46 clk_row_2_46 clk_row_2_o PTLCAP_M1
Xsum__out_entry_1_t0 sum__out_entry_1_i sum__out_entry_1_1 PTLCAP_M1
Xsum__out_entry_1_t1 sum__out_entry_1_1 sum__out_entry_1_2 BEND_PTL_M1
Xsum__out_entry_1_t2 sum__out_entry_1_2 sum__out_entry_1_3 PTL_M1
Xsum__out_entry_1_t3 sum__out_entry_1_3 sum__out_entry_1_4 PTL_M1
Xsum__out_entry_1_t4 sum__out_entry_1_4 sum__out_entry_1_5 PTL_M1
Xsum__out_entry_1_t5 sum__out_entry_1_5 sum__out_entry_1_6 PTL_M1
Xsum__out_entry_1_t6 sum__out_entry_1_6 sum__out_entry_1_7 BEND_PTL_M1
Xsum__out_entry_1_t7 sum__out_entry_1_7 sum__out_entry_1_8 PTL_M1
Xsum__out_entry_1_t8 sum__out_entry_1_8 sum__out_entry_1_9 PTL_M1
Xsum__out_entry_1_t9 sum__out_entry_1_9 sum__out_entry_1_10 PTL_M1
Xsum__out_entry_1_t10 sum__out_entry_1_10 sum__out_entry_1_11 PTL_M1
Xsum__out_entry_1_t11 sum__out_entry_1_11 sum__out_entry_1_12 PTL_M1
Xsum__out_entry_1_t12 sum__out_entry_1_12 sum__out_entry_1_13 PTL_M1
Xsum__out_entry_1_t13 sum__out_entry_1_13 sum__out_entry_1_14 PTL_M1
Xsum__out_entry_1_t14 sum__out_entry_1_14 sum__out_entry_1_15 PTL_M1
Xsum__out_entry_1_t15 sum__out_entry_1_15 sum__out_entry_1_16 PTL_M1
Xsum__out_entry_1_t16 sum__out_entry_1_16 sum__out_entry_1_17 PTL_M1
Xsum__out_entry_1_t17 sum__out_entry_1_17 sum__out_entry_1_18 PTL_M1
Xsum__out_entry_1_t18 sum__out_entry_1_18 sum__out_entry_1_19 PTL_M1
Xsum__out_entry_1_t19 sum__out_entry_1_19 sum__out_entry_1_20 PTL_M1
Xsum__out_entry_1_t20 sum__out_entry_1_20 sum__out_entry_1_21 PTL_M1
Xsum__out_entry_1_t21 sum__out_entry_1_21 sum__out_entry_1_22 PTL_M1
Xsum__out_entry_1_t22 sum__out_entry_1_22 sum__out_entry_1_23 PTL_M1
Xsum__out_entry_1_t23 sum__out_entry_1_23 sum__out_entry_1_24 PTL_M1
Xsum__out_entry_1_t24 sum__out_entry_1_24 sum__out_entry_1_25 PTL_M1
Xsum__out_entry_1_t25 sum__out_entry_1_25 sum__out_entry_1_26 PTL_M1
Xsum__out_entry_1_t26 sum__out_entry_1_26 sum__out_entry_1_27 PTL_M1
Xsum__out_entry_1_t27 sum__out_entry_1_27 sum__out_entry_1_28 BEND_PTL_M1
Xsum__out_entry_1_t28 sum__out_entry_1_28 sum__out_entry_1_o PTLCAP_M1
Xclk_spine_1_t0 clk_spine_1_i clk_spine_1_1 PTLCAP_M1
Xclk_spine_1_t1 clk_spine_1_1 clk_spine_1_2 PTL_M1
Xclk_spine_1_t2 clk_spine_1_2 clk_spine_1_3 PTL_M1
Xclk_spine_1_t3 clk_spine_1_3 clk_spine_1_4 PTL_M1
Xclk_spine_1_t4 clk_spine_1_4 clk_spine_1_5 PTL_M1
Xclk_spine_1_t5 clk_spine_1_5 clk_spine_1_6 PTL_M1
Xclk_spine_1_t6 clk_spine_1_6 clk_spine_1_7 PTL_M1
Xclk_spine_1_t7 clk_spine_1_7 clk_spine_1_8 PTL_M1
Xclk_spine_1_t8 clk_spine_1_8 clk_spine_1_9 PTL_M1
Xclk_spine_1_t9 clk_spine_1_9 clk_spine_1_10 PTL_M1
Xclk_spine_1_t10 clk_spine_1_10 clk_spine_1_11 PTL_M1
Xclk_spine_1_t11 clk_spine_1_11 clk_spine_1_12 PTL_M1
Xclk_spine_1_t12 clk_spine_1_12 clk_spine_1_13 PTL_M1
Xclk_spine_1_t13 clk_spine_1_13 clk_spine_1_14 PTL_M1
Xclk_spine_1_t14 clk_spine_1_14 clk_spine_1_15 PTL_M1
Xclk_spine_1_t15 clk_spine_1_15 clk_spine_1_16 PTL_M1
Xclk_spine_1_t16 clk_spine_1_16 clk_spine_1_17 PTL_M1
Xclk_spine_1_t17 clk_spine_1_17 clk_spine_1_18 PTL_M1
Xclk_spine_1_t18 clk_spine_1_18 clk_spine_1_19 BEND_PTL_M1
Xclk_spine_1_t19 clk_spine_1_19 clk_spine_1_20 PTL_M1
Xclk_spine_1_t20 clk_spine_1_20 clk_spine_1_21 PTL_M1
Xclk_spine_1_t21 clk_spine_1_21 clk_spine_1_22 BEND_PTL_M1
Xclk_spine_1_t22 clk_spine_1_22 clk_spine_1_23 PTL_M1
Xclk_spine_1_t23 clk_spine_1_23 clk_spine_1_24 PTL_M1
Xclk_spine_1_t24 clk_spine_1_24 clk_spine_1_25 BEND_PTL_M1
Xclk_spine_1_t25 clk_spine_1_25 clk_spine_1_o PTLCAP_M1
Xp2_t0 p2_i p2_1 PTLCAP_M1
Xp2_t1 p2_1 p2_2 BEND_PTL_M1
Xp2_t2 p2_2 p2_3 PTL_M1
Xp2_t3 p2_3 p2_4 PTL_M1
Xp2_t4 p2_4 p2_5 PTL_M1
Xp2_t5 p2_5 p2_6 PTL_M1
Xp2_t6 p2_6 p2_7 PTL_M1
Xp2_t7 p2_7 p2_8 PTL_M1
Xp2_t8 p2_8 p2_9 PTL_M1
Xp2_t9 p2_9 p2_10 PTL_M1
Xp2_t10 p2_10 p2_11 PTL_M1
Xp2_t11 p2_11 p2_12 PTL_M1
Xp2_t12 p2_12 p2_13 PTL_M1
Xp2_t13 p2_13 p2_14 PTL_M1
Xp2_t14 p2_14 p2_15 PTL_M1
Xp2_t15 p2_15 p2_16 PTL_M1
Xp2_t16 p2_16 p2_17 PTL_M1
Xp2_t17 p2_17 p2_18 PTL_M1
Xp2_t18 p2_18 p2_19 PTL_M1
Xp2_t19 p2_19 p2_20 PTL_M1
Xp2_t20 p2_20 p2_21 PTL_M1
Xp2_t21 p2_21 p2_22 PTL_M1
Xp2_t22 p2_22 p2_23 BEND_PTL_M1
Xp2_t23 p2_23 p2_24 PTL_M1
Xp2_t24 p2_24 p2_25 PTL_M1
Xp2_t25 p2_25 p2_26 PTL_M1
Xp2_t26 p2_26 p2_27 PTL_M1
Xp2_t27 p2_27 p2_28 PTL_M1
Xp2_t28 p2_28 p2_29 BEND_PTL_M1
Xp2_t29 p2_29 p2_o PTLCAP_M1
Xa__spl_7_t0 a__spl_7_i a__spl_7_1 PTLCAP_M3
Xa__spl_7_t1 a__spl_7_1 a__spl_7_2 PTL_M3
Xa__spl_7_t2 a__spl_7_2 a__spl_7_3 PTL_M3
Xa__spl_7_t3 a__spl_7_3 a__spl_7_4 PTL_M3
Xa__spl_7_t4 a__spl_7_4 a__spl_7_5 PTL_M3
Xa__spl_7_t5 a__spl_7_5 a__spl_7_6 BEND_PTL_M3
Xa__spl_7_t6 a__spl_7_6 a__spl_7_7 PTL_M3
Xa__spl_7_t7 a__spl_7_7 a__spl_7_8 PTL_M3
Xa__spl_7_t8 a__spl_7_8 a__spl_7_9 PTL_M3
Xa__spl_7_t9 a__spl_7_9 a__spl_7_10 PTL_M3
Xa__spl_7_t10 a__spl_7_10 a__spl_7_11 PTL_M3
Xa__spl_7_t11 a__spl_7_11 a__spl_7_12 PTL_M3
Xa__spl_7_t12 a__spl_7_12 a__spl_7_13 PTL_M3
Xa__spl_7_t13 a__spl_7_13 a__spl_7_14 PTL_M3
Xa__spl_7_t14 a__spl_7_14 a__spl_7_15 PTL_M3
Xa__spl_7_t15 a__spl_7_15 a__spl_7_16 PTL_M3
Xa__spl_7_t16 a__spl_7_16 a__spl_7_17 PTL_M3
Xa__spl_7_t17 a__spl_7_17 a__spl_7_18 PTL_M3
Xa__spl_7_t18 a__spl_7_18 a__spl_7_o PTLCAP_M3
Xcin__spl_3__ff_3_t0 cin__spl_3__ff_3_i cin__spl_3__ff_3_1 PTLCAP_M3
Xcin__spl_3__ff_3_t1 cin__spl_3__ff_3_1 cin__spl_3__ff_3_2 PTL_M3
Xcin__spl_3__ff_3_t2 cin__spl_3__ff_3_2 cin__spl_3__ff_3_3 BEND_PTL_M3
Xcin__spl_3__ff_3_t3 cin__spl_3__ff_3_3 cin__spl_3__ff_3_4 PTL_M3
Xcin__spl_3__ff_3_t4 cin__spl_3__ff_3_4 cin__spl_3__ff_3_5 PTL_M3
Xcin__spl_3__ff_3_t5 cin__spl_3__ff_3_5 cin__spl_3__ff_3_6 PTL_M3
Xcin__spl_3__ff_3_t6 cin__spl_3__ff_3_6 cin__spl_3__ff_3_7 PTL_M3
Xcin__spl_3__ff_3_t7 cin__spl_3__ff_3_7 cin__spl_3__ff_3_8 PTL_M3
Xcin__spl_3__ff_3_t8 cin__spl_3__ff_3_8 cin__spl_3__ff_3_9 PTL_M3
Xcin__spl_3__ff_3_t9 cin__spl_3__ff_3_9 cin__spl_3__ff_3_10 PTL_M3
Xcin__spl_3__ff_3_t10 cin__spl_3__ff_3_10 cin__spl_3__ff_3_11 PTL_M3
Xcin__spl_3__ff_3_t11 cin__spl_3__ff_3_11 cin__spl_3__ff_3_12 PTL_M3
Xcin__spl_3__ff_3_t12 cin__spl_3__ff_3_12 cin__spl_3__ff_3_13 PTL_M3
Xcin__spl_3__ff_3_t13 cin__spl_3__ff_3_13 cin__spl_3__ff_3_14 PTL_M3
Xcin__spl_3__ff_3_t14 cin__spl_3__ff_3_14 cin__spl_3__ff_3_15 PTL_M3
Xcin__spl_3__ff_3_t15 cin__spl_3__ff_3_15 cin__spl_3__ff_3_16 PTL_M3
Xcin__spl_3__ff_3_t16 cin__spl_3__ff_3_16 cin__spl_3__ff_3_17 PTL_M3
Xcin__spl_3__ff_3_t17 cin__spl_3__ff_3_17 cin__spl_3__ff_3_18 PTL_M3
Xcin__spl_3__ff_3_t18 cin__spl_3__ff_3_18 cin__spl_3__ff_3_19 BEND_PTL_M3
Xcin__spl_3__ff_3_t19 cin__spl_3__ff_3_19 cin__spl_3__ff_3_20 PTL_M3
Xcin__spl_3__ff_3_t20 cin__spl_3__ff_3_20 cin__spl_3__ff_3_21 PTL_M3
Xcin__spl_3__ff_3_t21 cin__spl_3__ff_3_21 cin__spl_3__ff_3_22 PTL_M3
Xcin__spl_3__ff_3_t22 cin__spl_3__ff_3_22 cin__spl_3__ff_3_23 PTL_M3
Xcin__spl_3__ff_3_t23 cin__spl_3__ff_3_23 cin__spl_3__ff_3_24 PTL_M3
Xcin__spl_3__ff_3_t24 cin__spl_3__ff_3_24 cin__spl_3__ff_3_25 BEND_PTL_M3
Xcin__spl_3__ff_3_t25 cin__spl_3__ff_3_25 cin__spl_3__ff_3_o PTLCAP_M3
Xcin__spl_4__ff_2_t0 cin__spl_4__ff_2_i cin__spl_4__ff_2_1 PTLCAP_M3
Xcin__spl_4__ff_2_t1 cin__spl_4__ff_2_1 cin__spl_4__ff_2_2 BEND_PTL_M3
Xcin__spl_4__ff_2_t2 cin__spl_4__ff_2_2 cin__spl_4__ff_2_3 PTL_M3
Xcin__spl_4__ff_2_t3 cin__spl_4__ff_2_3 cin__spl_4__ff_2_4 PTL_M3
Xcin__spl_4__ff_2_t4 cin__spl_4__ff_2_4 cin__spl_4__ff_2_5 PTL_M3
Xcin__spl_4__ff_2_t5 cin__spl_4__ff_2_5 cin__spl_4__ff_2_6 PTL_M3
Xcin__spl_4__ff_2_t6 cin__spl_4__ff_2_6 cin__spl_4__ff_2_7 PTL_M3
Xcin__spl_4__ff_2_t7 cin__spl_4__ff_2_7 cin__spl_4__ff_2_8 PTL_M3
Xcin__spl_4__ff_2_t8 cin__spl_4__ff_2_8 cin__spl_4__ff_2_9 PTL_M3
Xcin__spl_4__ff_2_t9 cin__spl_4__ff_2_9 cin__spl_4__ff_2_10 PTL_M3
Xcin__spl_4__ff_2_t10 cin__spl_4__ff_2_10 cin__spl_4__ff_2_11 PTL_M3
Xcin__spl_4__ff_2_t11 cin__spl_4__ff_2_11 cin__spl_4__ff_2_12 PTL_M3
Xcin__spl_4__ff_2_t12 cin__spl_4__ff_2_12 cin__spl_4__ff_2_13 PTL_M3
Xcin__spl_4__ff_2_t13 cin__spl_4__ff_2_13 cin__spl_4__ff_2_14 PTL_M3
Xcin__spl_4__ff_2_t14 cin__spl_4__ff_2_14 cin__spl_4__ff_2_15 PTL_M3
Xcin__spl_4__ff_2_t15 cin__spl_4__ff_2_15 cin__spl_4__ff_2_16 PTL_M3
Xcin__spl_4__ff_2_t16 cin__spl_4__ff_2_16 cin__spl_4__ff_2_17 PTL_M3
Xcin__spl_4__ff_2_t17 cin__spl_4__ff_2_17 cin__spl_4__ff_2_18 PTL_M3
Xcin__spl_4__ff_2_t18 cin__spl_4__ff_2_18 cin__spl_4__ff_2_19 PTL_M3
Xcin__spl_4__ff_2_t19 cin__spl_4__ff_2_19 cin__spl_4__ff_2_20 PTL_M3
Xcin__spl_4__ff_2_t20 cin__spl_4__ff_2_20 cin__spl_4__ff_2_21 PTL_M3
Xcin__spl_4__ff_2_t21 cin__spl_4__ff_2_21 cin__spl_4__ff_2_22 PTL_M3
Xcin__spl_4__ff_2_t22 cin__spl_4__ff_2_22 cin__spl_4__ff_2_23 PTL_M3
Xcin__spl_4__ff_2_t23 cin__spl_4__ff_2_23 cin__spl_4__ff_2_24 PTL_M3
Xcin__spl_4__ff_2_t24 cin__spl_4__ff_2_24 cin__spl_4__ff_2_25 BEND_PTL_M3
Xcin__spl_4__ff_2_t25 cin__spl_4__ff_2_25 cin__spl_4__ff_2_o PTLCAP_M3
Xclk_row_3_t0 clk_row_3_i clk_row_3_1 PTLCAP_M3
Xclk_row_3_t1 clk_row_3_1 clk_row_3_2 PTL_M3
Xclk_row_3_t2 clk_row_3_2 clk_row_3_3 PTL_M3
Xclk_row_3_t3 clk_row_3_3 clk_row_3_4 PTL_M3
Xclk_row_3_t4 clk_row_3_4 clk_row_3_5 PTL_M3
Xclk_row_3_t5 clk_row_3_5 clk_row_3_6 BEND_PTL_M3
Xclk_row_3_t6 clk_row_3_6 clk_row_3_7 PTL_M3
Xclk_row_3_t7 clk_row_3_7 clk_row_3_8 PTL_M3
Xclk_row_3_t8 clk_row_3_8 clk_row_3_9 PTL_M3
Xclk_row_3_t9 clk_row_3_9 clk_row_3_10 PTL_M3
Xclk_row_3_t10 clk_row_3_10 clk_row_3_11 PTL_M3
Xclk_row_3_t11 clk_row_3_11 clk_row_3_12 PTL_M3
Xclk_row_3_t12 clk_row_3_12 clk_row_3_13 PTL_M3
Xclk_row_3_t13 clk_row_3_13 clk_row_3_14 PTL_M3
Xclk_row_3_t14 clk_row_3_14 clk_row_3_15 PTL_M3
Xclk_row_3_t15 clk_row_3_15 clk_row_3_16 PTL_M3
Xclk_row_3_t16 clk_row_3_16 clk_row_3_17 PTL_M3
Xclk_row_3_t17 clk_row_3_17 clk_row_3_18 PTL_M3
Xclk_row_3_t18 clk_row_3_18 clk_row_3_19 PTL_M3
Xclk_row_3_t19 clk_row_3_19 clk_row_3_20 PTL_M3
Xclk_row_3_t20 clk_row_3_20 clk_row_3_21 PTL_M3
Xclk_row_3_t21 clk_row_3_21 clk_row_3_22 PTL_M3
Xclk_row_3_t22 clk_row_3_22 clk_row_3_23 PTL_M3
Xclk_row_3_t23 clk_row_3_23 clk_row_3_24 PTL_M3
Xclk_row_3_t24 clk_row_3_24 clk_row_3_25 BEND_PTL_M3
Xclk_row_3_t25 clk_row_3_25 clk_row_3_o PTLCAP_M3
Xp1_t0 p1_i p1_1 PTLCAP_M3
Xp1_t1 p1_1 p1_2 BEND_PTL_M3
Xp1_t2 p1_2 p1_3 PTL_M3
Xp1_t3 p1_3 p1_4 PTL_M3
Xp1_t4 p1_4 p1_5 PTL_M3
Xp1_t5 p1_5 p1_6 PTL_M3
Xp1_t6 p1_6 p1_7 PTL_M3
Xp1_t7 p1_7 p1_8 PTL_M3
Xp1_t8 p1_8 p1_9 PTL_M3
Xp1_t9 p1_9 p1_10 PTL_M3
Xp1_t10 p1_10 p1_11 PTL_M3
Xp1_t11 p1_11 p1_12 PTL_M3
Xp1_t12 p1_12 p1_13 PTL_M3
Xp1_t13 p1_13 p1_14 PTL_M3
Xp1_t14 p1_14 p1_15 PTL_M3
Xp1_t15 p1_15 p1_16 PTL_M3
Xp1_t16 p1_16 p1_17 PTL_M3
Xp1_t17 p1_17 p1_18 BEND_PTL_M3
Xp1_t18 p1_18 p1_19 BEND_PTL_M3
Xp1_t19 p1_19 p1_20 PTL_M3
Xp1_t20 p1_20 p1_21 PTL_M3
Xp1_t21 p1_21 p1_22 PTL_M3
Xp1_t22 p1_22 p1_23 PTL_M3
Xp1_t23 p1_23 p1_24 PTL_M3
Xp1_t24 p1_24 p1_25 PTL_M3
Xp1_t25 p1_25 p1_26 BEND_PTL_M3
Xp1_t26 p1_26 p1_27 PTL_M3
Xp1_t27 p1_27 p1_28 PTL_M3
Xp1_t28 p1_28 p1_29 BEND_PTL_M3
Xp1_t29 p1_29 p1_o PTLCAP_M3
Xsum_t0 sum_i sum_1 PTLCAP_M3
Xsum_t1 sum_1 sum_2 BEND_PTL_M3
Xsum_t2 sum_2 sum_3 PTL_M3
Xsum_t3 sum_3 sum_4 PTL_M3
Xsum_t4 sum_4 sum_5 PTL_M3
Xsum_t5 sum_5 sum_6 PTL_M3
Xsum_t6 sum_6 sum_7 PTL_M3
Xsum_t7 sum_7 sum_8 PTL_M3
Xsum_t8 sum_8 sum_9 PTL_M3
Xsum_t9 sum_9 sum_10 PTL_M3
Xsum_t10 sum_10 sum_11 PTL_M3
Xsum_t11 sum_11 sum_12 PTL_M3
Xsum_t12 sum_12 sum_13 PTL_M3
Xsum_t13 sum_13 sum_14 PTL_M3
Xsum_t14 sum_14 sum_15 PTL_M3
Xsum_t15 sum_15 sum_16 PTL_M3
Xsum_t16 sum_16 sum_17 PTL_M3
Xsum_t17 sum_17 sum_18 PTL_M3
Xsum_t18 sum_18 sum_19 PTL_M3
Xsum_t19 sum_19 sum_20 PTL_M3
Xsum_t20 sum_20 sum_21 PTL_M3
Xsum_t21 sum_21 sum_22 PTL_M3
Xsum_t22 sum_22 sum_23 PTL_M3
Xsum_t23 sum_23 sum_24 PTL_M3
Xsum_t24 sum_24 sum_25 PTL_M3
Xsum_t25 sum_25 sum_26 PTL_M3
Xsum_t26 sum_26 sum_27 PTL_M3
Xsum_t27 sum_27 sum_28 PTL_M3
Xsum_t28 sum_28 sum_29 BEND_PTL_M3
Xsum_t29 sum_29 sum_30 PTL_M3
Xsum_t30 sum_30 sum_31 PTL_M3
Xsum_t31 sum_31 sum_o PTLCAP_M3
Xcin_t0 cin_i cin_1 PTLCAP_M3
Xcin_t1 cin_1 cin_2 PTL_M3
Xcin_t2 cin_2 cin_3 PTL_M3
Xcin_t3 cin_3 cin_4 PTL_M3
Xcin_t4 cin_4 cin_5 PTL_M3
Xcin_t5 cin_5 cin_6 PTL_M3
Xcin_t6 cin_6 cin_7 PTL_M3
Xcin_t7 cin_7 cin_8 PTL_M3
Xcin_t8 cin_8 cin_9 PTL_M3
Xcin_t9 cin_9 cin_10 PTL_M3
Xcin_t10 cin_10 cin_11 PTL_M3
Xcin_t11 cin_11 cin_12 PTL_M3
Xcin_t12 cin_12 cin_13 PTL_M3
Xcin_t13 cin_13 cin_14 PTL_M3
Xcin_t14 cin_14 cin_15 PTL_M3
Xcin_t15 cin_15 cin_16 PTL_M3
Xcin_t16 cin_16 cin_17 PTL_M3
Xcin_t17 cin_17 cin_18 PTL_M3
Xcin_t18 cin_18 cin_19 PTL_M3
Xcin_t19 cin_19 cin_20 PTL_M3
Xcin_t20 cin_20 cin_21 PTL_M3
Xcin_t21 cin_21 cin_22 PTL_M3
Xcin_t22 cin_22 cin_23 PTL_M3
Xcin_t23 cin_23 cin_24 PTL_M3
Xcin_t24 cin_24 cin_25 PTL_M3
Xcin_t25 cin_25 cin_26 PTL_M3
Xcin_t26 cin_26 cin_27 PTL_M3
Xcin_t27 cin_27 cin_28 PTL_M3
Xcin_t28 cin_28 cin_29 PTL_M3
Xcin_t29 cin_29 cin_30 PTL_M3
Xcin_t30 cin_30 cin_31 PTL_M3
Xcin_t31 cin_31 cin_32 PTL_M3
Xcin_t32 cin_32 cin_33 PTL_M3
Xcin_t33 cin_33 cin_34 BEND_PTL_M3
Xcin_t34 cin_34 cin_35 PTL_M3
Xcin_t35 cin_35 cin_36 BEND_PTL_M3
Xcin_t36 cin_36 cin_37 PTL_M3
Xcin_t37 cin_37 cin_38 PTL_M3
Xcin_t38 cin_38 cin_o PTLCAP_M3
Xclk_row_1_t0 clk_row_1_i clk_row_1_1 PTLCAP_M3
Xclk_row_1_t1 clk_row_1_1 clk_row_1_2 PTL_M3
Xclk_row_1_t2 clk_row_1_2 clk_row_1_3 PTL_M3
Xclk_row_1_t3 clk_row_1_3 clk_row_1_4 PTL_M3
Xclk_row_1_t4 clk_row_1_4 clk_row_1_5 PTL_M3
Xclk_row_1_t5 clk_row_1_5 clk_row_1_6 PTL_M3
Xclk_row_1_t6 clk_row_1_6 clk_row_1_7 PTL_M3
Xclk_row_1_t7 clk_row_1_7 clk_row_1_8 PTL_M3
Xclk_row_1_t8 clk_row_1_8 clk_row_1_9 BEND_PTL_M3
Xclk_row_1_t9 clk_row_1_9 clk_row_1_10 PTL_M3
Xclk_row_1_t10 clk_row_1_10 clk_row_1_11 PTL_M3
Xclk_row_1_t11 clk_row_1_11 clk_row_1_12 PTL_M3
Xclk_row_1_t12 clk_row_1_12 clk_row_1_13 PTL_M3
Xclk_row_1_t13 clk_row_1_13 clk_row_1_14 PTL_M3
Xclk_row_1_t14 clk_row_1_14 clk_row_1_15 PTL_M3
Xclk_row_1_t15 clk_row_1_15 clk_row_1_16 PTL_M3
Xclk_row_1_t16 clk_row_1_16 clk_row_1_17 PTL_M3
Xclk_row_1_t17 clk_row_1_17 clk_row_1_18 PTL_M3
Xclk_row_1_t18 clk_row_1_18 clk_row_1_19 PTL_M3
Xclk_row_1_t19 clk_row_1_19 clk_row_1_20 PTL_M3
Xclk_row_1_t20 clk_row_1_20 clk_row_1_21 PTL_M3
Xclk_row_1_t21 clk_row_1_21 clk_row_1_22 PTL_M3
Xclk_row_1_t22 clk_row_1_22 clk_row_1_23 PTL_M3
Xclk_row_1_t23 clk_row_1_23 clk_row_1_24 PTL_M3
Xclk_row_1_t24 clk_row_1_24 clk_row_1_25 PTL_M3
Xclk_row_1_t25 clk_row_1_25 clk_row_1_26 PTL_M3
Xclk_row_1_t26 clk_row_1_26 clk_row_1_27 PTL_M3
Xclk_row_1_t27 clk_row_1_27 clk_row_1_28 PTL_M3
Xclk_row_1_t28 clk_row_1_28 clk_row_1_29 PTL_M3
Xclk_row_1_t29 clk_row_1_29 clk_row_1_30 BEND_PTL_M3
Xclk_row_1_t30 clk_row_1_30 clk_row_1_31 PTL_M3
Xclk_row_1_t31 clk_row_1_31 clk_row_1_32 PTL_M3
Xclk_row_1_t32 clk_row_1_32 clk_row_1_33 PTL_M3
Xclk_row_1_t33 clk_row_1_33 clk_row_1_34 PTL_M3
Xclk_row_1_t34 clk_row_1_34 clk_row_1_35 PTL_M3
Xclk_row_1_t35 clk_row_1_35 clk_row_1_36 PTL_M3
Xclk_row_1_t36 clk_row_1_36 clk_row_1_37 PTL_M3
Xclk_row_1_t37 clk_row_1_37 clk_row_1_38 PTL_M3
Xclk_row_1_t38 clk_row_1_38 clk_row_1_39 PTL_M3
Xclk_row_1_t39 clk_row_1_39 clk_row_1_40 PTL_M3
Xclk_row_1_t40 clk_row_1_40 clk_row_1_41 PTL_M3
Xclk_row_1_t41 clk_row_1_41 clk_row_1_42 PTL_M3
Xclk_row_1_t42 clk_row_1_42 clk_row_1_43 PTL_M3
Xclk_row_1_t43 clk_row_1_43 clk_row_1_44 PTL_M3
Xclk_row_1_t44 clk_row_1_44 clk_row_1_45 PTL_M3
Xclk_row_1_t45 clk_row_1_45 clk_row_1_46 PTL_M3
Xclk_row_1_t46 clk_row_1_46 clk_row_1_47 PTL_M3
Xclk_row_1_t47 clk_row_1_47 clk_row_1_48 PTL_M3
Xclk_row_1_t48 clk_row_1_48 clk_row_1_o PTLCAP_M3
XTHmitll_XORT_1 a__spl_7_o b__spl_1_o THmitll_XORT__clkbuf_2_o s1_i THmitll_XORT
XTHmitll_AND2T_2 a__spl_8_o b__spl_2_o clk_row_1__spl_3_o p1_i THmitll_AND2T
XTHmitll_XORT_3 s1__spl_5_o cin__spl_3__ff_3_o THmitll_XORT__clkbuf_1_o sum__out_entry_1_i THmitll_XORT
XTHmitll_AND2T_4 s1__spl_6_o cin__spl_4__ff_2_o clk_row_2__spl_3_o p2_i THmitll_AND2T
XTHmitll_OR2T_5 p1__ff_1_o p2_o clk_row_3__spl_2_o cout_i THmitll_OR2T
XTHmitll_SPLITT_6 b_o b__spl_2_i b__spl_1_i THmitll_SPLITT
XTHmitll_SPLITT_7 cin__ff_1_o cin__spl_4__ff_2_i cin__spl_3__ff_3_i THmitll_SPLITT
XTHmitll_SPLITT_8 s1_o s1__spl_6_i s1__spl_5_i THmitll_SPLITT
XTHmitll_SPLITT_9 a_o a__spl_8_i a__spl_7_i THmitll_SPLITT
XTHmitll_DFFT_10 p1_o clk_row_2__spl_2_o p1__ff_1_i THmitll_DFFT
XTHmitll_DFFT_11 cin_o clk_row_1__spl_2_o cin__ff_1_i THmitll_DFFT
XTHmitll_DFFT_12 sum__out_entry_1_o clk_row_3__spl_1_o sum_i THmitll_DFFT
XTHmitll_SPLITT_1_0 clk_row_1_o clk_row_1__spl_4_i clk_row_1__spl_1_i THmitll_SPLITT
XTHmitll_SPLITT_1_1 clk_row_1__spl_1_o clk_row_1__spl_3_i clk_row_1__spl_2_i THmitll_SPLITT
XTHmitll_BUFFT_1_4 clk_row_1__spl_4_o THmitll_XORT__clkbuf_2_i THmitll_BUFFT
XTHmitll_SPLITT_2_0 clk_row_2_o clk_row_2__spl_4_i clk_row_2__spl_1_i THmitll_SPLITT
XTHmitll_SPLITT_2_1 clk_row_2__spl_1_o clk_row_2__spl_3_i clk_row_2__spl_2_i THmitll_SPLITT
XTHmitll_BUFFT_2_4 clk_row_2__spl_4_o THmitll_XORT__clkbuf_1_i THmitll_BUFFT
XTHmitll_SPLITT_3_0 clk_row_3_o clk_row_3__spl_2_i clk_row_3__spl_1_i THmitll_SPLITT
XTHmitll_SPLITT_sp0 clk_o clk_spine_1_i clk_row_3_i THmitll_SPLITT
XTHmitll_SPLITT_sp1 clk_spine_1_o clk_row_1_i clk_row_2_i THmitll_SPLITT
